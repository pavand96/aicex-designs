*TB LELO_TWO_STAGE_MILLER — Noise (vos passed in by orchestrator)
.include ../../../work/xsch/LELO_TWO_STAGE_MILLER.spice
.option TNOM=27 GMIN=1e-12 reltol=1e-3 srcsteps=10 itl1=300 itl6=200
.option sparse

.param vcm = 'vdda/2'
.param ibias_val = 10u
.param CL_val = 1p
.param vos = {VOS}

VSS    VSS    0      dc 0
VDD    VDD    0      dc {vdda}
IIBIAS VSS    IBIAS  dc {ibias_val}
VVINP  VINP   0      dc {vos} ac 1
VVINN  VINN   0      dc {vcm}
CL     VOUT   VSS    {CL_val}

.include ../xdut.spi

.nodeset v(ibias)        = 0.66
.nodeset v(xdut.ntail)   = 0.20
.nodeset v(xdut.n1)      = 1.10
.nodeset v(xdut.vout1)   = 0.55
.nodeset v(xdut.ncc)     = {vcm}
.nodeset v(vout)         = {vcm}

.save all

.control
set num_threads=8
unset askquit
set filetype=ascii

ac dec 10 1 100Meg
let g_db = 20*log10(abs(v(vout)))
meas ac dc_gain_check FIND g_db AT=10
print dc_gain_check
setplot previous

noise v(VOUT) VVINP dec 50 1 1G 1
setplot noise1

let vn_in_rt  = sqrt(inoise_spectrum)
let vn_out_rt = sqrt(onoise_spectrum)

let vn_1Hz_in    = vn_in_rt[0]
let vn_10Hz_in   = vn_in_rt[50]
let vn_1kHz_in   = vn_in_rt[150]
let vn_100kHz_in = vn_in_rt[250]
let vn_1MHz_in   = vn_in_rt[300]
let vn_10MHz_in  = vn_in_rt[350]

let vn_1Hz_out   = vn_out_rt[0]
let vn_1kHz_out  = vn_out_rt[150]
let vn_100kHz_out= vn_out_rt[250]
let vn_10MHz_out = vn_out_rt[350]

let v2_in_cum  = integ(inoise_spectrum)
let v2_out_cum = integ(onoise_spectrum)

let vn_in_rms_to_f3db = sqrt(v2_in_cum[155])
let vn_in_rms_to_100k = sqrt(v2_in_cum[250])
let vn_in_rms_to_1M   = sqrt(v2_in_cum[300])
let vn_in_rms_to_GBW  = sqrt(v2_in_cum[358])

let vn_out_rms_to_f3db = sqrt(v2_out_cum[155])
let vn_out_rms_to_100k = sqrt(v2_out_cum[250])
let vn_out_rms_to_1M   = sqrt(v2_out_cum[300])
let vn_out_rms_to_GBW  = sqrt(v2_out_cum[358])

echo ""
echo "================ INPUT-REFERRED NOISE ================"
print vn_1Hz_in vn_10Hz_in vn_1kHz_in vn_100kHz_in vn_1MHz_in vn_10MHz_in
print vn_in_rms_to_f3db vn_in_rms_to_100k vn_in_rms_to_1M vn_in_rms_to_GBW
echo ""
echo "================ OUTPUT NOISE ================"
print vn_1Hz_out vn_1kHz_out vn_100kHz_out vn_10MHz_out
print vn_out_rms_to_f3db vn_out_rms_to_100k vn_out_rms_to_1M vn_out_rms_to_GBW

write {cicname}.raw
quit
.endc
.end
