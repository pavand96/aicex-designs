*TB LELO_TWO_STAGE_MILLER — Input-referred noise + integrated totals
.include ../../../work/xsch/LELO_TWO_STAGE_MILLER.spice
.option TNOM=27 GMIN=1e-12 reltol=1e-3 srcsteps=10 itl1=300 itl6=200
.option sparse

.param AVDD      = 1.8
.param vcm       = 0.9
.param vos       = 0.89979
.param ibias_val = 10u
.param CL_val    = 1p

VSS    VSS    0      dc 0
VDD    VDD    0      dc {AVDD}
IIBIAS VSS    IBIAS  dc {ibias_val}
VVINP  VINP   0      dc {vos} ac 1
VVINN  VINN   0      dc {vcm}
CL     VOUT   VSS    {CL_val}
.include ../xdut.spi

.nodeset v(ibias)        = 0.66
.nodeset v(xdut.ntail)   = 0.20
.nodeset v(xdut.n1)      = 1.10
.nodeset v(xdut.vout1)   = 0.55
.nodeset v(xdut.ncc)     = 0.90
.nodeset v(vout)         = 0.90

.save all

.control
set num_threads=8
unset askquit
set filetype=ascii

* AC pre-check that the OP gives expected gain
ac dec 10 1 100Meg
let g_db = 20*log10(abs(v(vout)))
meas ac dc_gain_check FIND g_db AT=10
print dc_gain_check
setplot previous

* Sweep 1 Hz .. 1 GHz, 50 pts/dec → 451 freq points
noise v(VOUT) VVINP dec 50 1 1G 1
setplot noise1

let vn_in_rt  = sqrt(inoise_spectrum)
let vn_out_rt = sqrt(onoise_spectrum)

* Spot V/sqrt(Hz) at decades  (idx = 50 * log10(f/fmin))
let vn_1Hz_in    = vn_in_rt[0]
let vn_10Hz_in   = vn_in_rt[50]
let vn_1kHz_in   = vn_in_rt[150]
let vn_100kHz_in = vn_in_rt[250]
let vn_1MHz_in   = vn_in_rt[300]
let vn_10MHz_in  = vn_in_rt[350]

let vn_1Hz_out   = vn_out_rt[0]
let vn_1kHz_out  = vn_out_rt[150]
let vn_100kHz_out= vn_out_rt[250]
let vn_10MHz_out = vn_out_rt[350]

* Cumulative integral of noise PSD vs frequency
let v2_in_cum  = integ(inoise_spectrum)
let v2_out_cum = integ(onoise_spectrum)

* Integrated input-referred RMS over various bands
let vn_in_rms_to_f3db    = sqrt(v2_in_cum[155])  $ ~1.4 kHz (closed-loop band for high gain config)
let vn_in_rms_to_100k    = sqrt(v2_in_cum[250])  $ 100 kHz
let vn_in_rms_to_1M      = sqrt(v2_in_cum[300])  $ 1 MHz
let vn_in_rms_to_GBW     = sqrt(v2_in_cum[358])  $ ~16 MHz

let vn_out_rms_to_f3db   = sqrt(v2_out_cum[155])
let vn_out_rms_to_100k   = sqrt(v2_out_cum[250])
let vn_out_rms_to_1M     = sqrt(v2_out_cum[300])
let vn_out_rms_to_GBW    = sqrt(v2_out_cum[358])

echo ""
echo "================ INPUT-REFERRED NOISE ================"
echo "Spot density (V/sqrt Hz):"
print vn_1Hz_in vn_10Hz_in vn_1kHz_in vn_100kHz_in vn_1MHz_in vn_10MHz_in
echo ""
echo "Integrated RMS, input-referred (V) [1 Hz → f_top]:"
print vn_in_rms_to_f3db
print vn_in_rms_to_100k
print vn_in_rms_to_1M
print vn_in_rms_to_GBW
echo ""
echo "================ OUTPUT NOISE ================"
echo "Spot density (V/sqrt Hz):"
print vn_1Hz_out vn_1kHz_out vn_100kHz_out vn_10MHz_out
echo ""
echo "Integrated RMS, output (V) [1 Hz → f_top]:"
print vn_out_rms_to_f3db
print vn_out_rms_to_100k
print vn_out_rms_to_1M
print vn_out_rms_to_GBW

* Dump CSV for plotting
wrdata noise_spectra.csv frequency vn_in_rt vn_out_rt

write {cicname}.raw
quit
.endc
.end
