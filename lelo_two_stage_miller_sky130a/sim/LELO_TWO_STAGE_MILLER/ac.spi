*TB LELO_TWO_STAGE_MILLER — Open-loop AC (vos passed in by orchestrator)
.include ../../../work/xsch/LELO_TWO_STAGE_MILLER.spice
.option TNOM=27 GMIN=1e-12 reltol=1e-3 srcsteps=10 itl1=300 itl6=200

.param vcm = 'vdda/2'
.param ibias_val = 10u
.param CL_val = 1p
.param vos = {VOS}

VSS    VSS    0      dc 0
VDD    VDD    0      dc {vdda}
IIBIAS VSS    IBIAS  dc {ibias_val}
VVINP  VINP   0      dc {vos} ac 1
VVINN  VINN   0      dc {vcm}
CL     VOUT   VSS    {CL_val}

.include ../xdut.spi

.nodeset v(ibias)        = 0.66
.nodeset v(xdut.ntail)   = 0.20
.nodeset v(xdut.n1)      = 1.10
.nodeset v(xdut.vout1)   = 0.55
.nodeset v(xdut.ncc)     = {vcm}
.nodeset v(vout)         = {vcm}

.save all

.control
set num_threads=8
unset askquit
set filetype=ascii

ac dec 100 1 1G

let mag_db = 20*log10(abs(v(vout)))
let ph_deg = 180/PI * cph(v(vout))

meas ac dc_gain_db FIND mag_db AT=10
let f3db_target = dc_gain_db - 3
meas ac f3db       WHEN mag_db = f3db_target
meas ac fgbw       WHEN mag_db = 0
meas ac phase_ugf  FIND ph_deg WHEN mag_db = 0
let pm = phase_ugf

echo ""
echo "================ AC SUMMARY ================"
print dc_gain_db
print f3db
print fgbw
print phase_ugf
print pm

write {cicname}.raw
quit
.endc
.end
