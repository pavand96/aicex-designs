*TB DC sweep — find true Vos (with srcsteps+nodeset for correct bias)
.include ../../../work/xsch/LELO_TWO_STAGE_MILLER.spice
.option TNOM=27 GMIN=1e-12 reltol=1e-3 srcsteps=10 itl1=300

.param AVDD = 1.8
.param vcm  = 0.9
.param ibias_val = 10u

VSS    VSS    0      dc 0
VDD    VDD    0      dc {AVDD}
VVINP  VINP   0      dc {vcm}
VVINN  VINN   0      dc {vcm}
IIBIAS VSS    IBIAS  dc {ibias_val}
.include ../xdut.spi

.nodeset v(ibias)        = 0.66
.nodeset v(xdut.ntail)   = 0.20
.nodeset v(xdut.n1)      = 1.10
.nodeset v(xdut.vout1)   = 0.55
.nodeset v(vout)         = 0.90

.save v(vout)

.control
set num_threads=8
unset askquit
set filetype=ascii
dc VVINP 0.88 0.92 0.0001
meas dc vos when v(vout) = 0.9
print vos
write {cicname}.raw
quit
.endc
.end
