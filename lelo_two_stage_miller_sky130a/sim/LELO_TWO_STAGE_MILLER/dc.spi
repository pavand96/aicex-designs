*TB DC sweep — find true Vos at the active corner (uses vdda from supply.spi)
.include ../../../work/xsch/LELO_TWO_STAGE_MILLER.spice
.option TNOM=27 GMIN=1e-12 reltol=1e-3 srcsteps=10 itl1=300

.param vcm = 'vdda/2'
.param ibias_val = 10u

VSS    VSS    0      dc 0
VDD    VDD    0      dc {vdda}
VVINP  VINP   0      dc {vcm}
VVINN  VINN   0      dc {vcm}
IIBIAS VSS    IBIAS  dc {ibias_val}
.include ../xdut.spi

.nodeset v(ibias)        = 0.66
.nodeset v(xdut.ntail)   = 0.20
.nodeset v(xdut.n1)      = 1.10
.nodeset v(xdut.vout1)   = 0.55
.nodeset v(vout)         = {vcm}

.save v(vout)

.control
set num_threads=8
unset askquit
set filetype=ascii
* Wide sweep: covers Vos shift across every corner
dc VVINP 0.50 1.30 0.0002
meas dc vos when v(vout) = 0.9
print vos
write {cicname}.raw
quit
.endc
.end
