*TB LELO_TWO_STAGE_MILLER — Closed-loop transient (unity-gain buffer): step + slew
.include ../../../work/xsch/LELO_TWO_STAGE_MILLER.spice
.option TNOM=27 GMIN=1e-12 reltol=1e-3 srcsteps=10 itl1=300 itl6=200

.param AVDD      = 1.8
.param vcm       = 0.9
.param ibias_val = 10u
.param CL_val    = 1p

VSS    VSS    0      dc 0
VDD    VDD    0      dc {AVDD}
IIBIAS VSS    IBIAS  dc {ibias_val}

* Unity-gain feedback: VINP = VOUT (VINP is the inverting input here
* because the open-loop transfer VINP→VOUT is inverting). VINN is driven.
EFB    VINP   0      vol = 'v(VOUT)'

* Stimulus on VINN: small step at 100 ns, large step at 500 ns
VVINN  VINN   0   PWL(0          {vcm}
+                    100n        {vcm}
+                    100.05n     {vcm + 0.01}
+                    500n        {vcm + 0.01}
+                    500.05n     {vcm + 0.30})

CL     VOUT   VSS    {CL_val}

.include ../xdut.spi

.ic v(vout) = 0.9
.ic v(xdut.vout1) = 0.55
.ic v(xdut.n1)    = 1.10
.ic v(xdut.ntail) = 0.20
.ic v(ibias)      = 0.66

.save v(VINP) v(VOUT)

.control
set num_threads=8
unset askquit
set filetype=ascii
tran 200p 1u uic

* Small step settling (100..500 ns)
meas tran vo_init_s   AVG  v(vout)  FROM=80n  TO=99n
meas tran vo_fin_s    AVG  v(vout)  FROM=480n TO=499n
meas tran vo_pp_s     PP   v(vout)  FROM=100n TO=500n

* Large step (500 ns onward) for slew
meas tran vo_init_l   AVG  v(vout)  FROM=480n TO=499n
meas tran vo_fin_l    AVG  v(vout)  FROM=950n TO=999n
let svd = abs(deriv(v(vout)))
meas tran sr_pos      MAX  svd      FROM=500n TO=600n

echo ""
echo "===== SMALL-SIGNAL CLOSED-LOOP STEP (10 mV) ====="
print vo_init_s vo_fin_s vo_pp_s
echo ""
echo "===== LARGE-SIGNAL SLEW (300 mV step) ====="
print vo_init_l vo_fin_l sr_pos
write {cicname}.raw
quit
.endc
.end
