** sch_path: /home/pavand96/pro/aicex/ip/lelo_pmodele_sky130a/design/LELO_PMODELE_SKY130A/LELO_PMODELE.sch
**.subckt LELO_PMODELE VDD VG VB VD
*.ipin VDD
*.ipin VG
*.ipin VB
*.ipin VD
XM2 VD VG VDD VB sky130_fd_pr__pfet_01v8 L=0.8000 W=80.00 nf=1 ad=23.2 as=23.2 pd=160.58 ps=160.58 nrd=0.003625 nrs=0.003625 sa=0
+ sb=0 sd=0 mult=1 m=1
**.ends
.end
