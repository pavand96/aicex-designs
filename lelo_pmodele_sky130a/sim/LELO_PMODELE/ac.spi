*TB_LELO_PMODELE - AC Analysis at Fixed Bias (for AC measurements)
*Single-point AC analysis with DC bias control
*-----------------------------------------------------------------
* Include
*-----------------------------------------------------------------
#ifdef Lay
.include ../../../work/lpe/LELO_PMODELE_lpe.spi
#else
.include ../../../work/xsch/LELO_PMODELE.spice
#endif

*-----------------------------------------------------------------
* OPTIONS
*-----------------------------------------------------------------
.option TNOM=27 GMIN=1e-15 reltol=1e-3

*-----------------------------------------------------------------
* INDEPENDENT SOURCES - Direct VGS and VDS control (PMOS: VDD = 1.8V)
*-----------------------------------------------------------------
VDD   VDD   0    dc 1.8
VGS   VIN   VDD  dc 0 ac 0.01
VDS   VOUT  VDD  dc -0.5 ac 0

*-----------------------------------------------------------------
* DUT
*-----------------------------------------------------------------
.include ../xdut.spi

*-----------------------------------------------------------------
* AC ANALYSIS
*-----------------------------------------------------------------
.ac dec 10 1k 10G

*-----------------------------------------------------------------
* SAVE DATA
*-----------------------------------------------------------------
.save all
.save v(VIN) v(VOUT) i(VDD)

*-----------------------------------------------------------------
* NGSPICE control
*-----------------------------------------------------------------
.control
set num_threads=8
unset askquit
set filetype=ascii

run
write {cicname}.raw

quit
.endc

.end
