*TB LELO_FDA_MILLER — Open-loop differential AC
.include ../../../work/xsch/LELO_FDA_MILLER.spice
.option TNOM=27 GMIN=1e-12 reltol=1e-3 srcsteps=20 itl1=500 itl6=300 abstol=1e-12

.param vcm = 'vdda/2'
.param ibias_val = 100u
.param CL_val    = 2.5p
.param vos       = {VOS}

VSS    VSS    0      dc 0
VDD    VDD    0      dc {vdda}
VVCMREF VCMREF 0     dc {vcm}
* Differential AC stim: +0.5 on VINP, -0.5 on VINN -> Vid = 1
VVINP  VINP   0      dc {vos}    ac  0.5
VVINN  VINN   0      dc {vcm}    ac -0.5
IIBIAS VSS    IBIAS  dc {ibias_val}
CLP    VOUTP  VSS    {CL_val}
CLN    VOUTN  VSS    {CL_val}
.include ../xdut.spi

.nodeset v(ibias)        = 0.85
.nodeset v(xdut.pbias)   = 0.64
.nodeset v(xdut.ntail)   = 0.25
.nodeset v(xdut.voutp1)  = 0.77
.nodeset v(xdut.voutn1)  = 0.77
.nodeset v(xdut.vctrl)  = 0.74
.nodeset v(xdut.vd)  = 0.59
.nodeset v(voutp)        = {vcm}
.nodeset v(voutn)        = {vcm}
.nodeset v(xdut.stailp)  = 0.20
.nodeset v(xdut.stailn)  = 0.20
.nodeset v(xdut.nccp)    = {vcm}
.nodeset v(xdut.nccn)    = {vcm}

.ic v(xdut.vctrl)  = 0.74
.ic v(xdut.pbias) = 0.64
.ic v(xdut.ntail) = 0.25
.ic v(voutp)      = {vcm}
.ic v(voutn)      = {vcm}
.ic v(xdut.voutp1)  = 0.77
.ic v(xdut.voutn1)  = 0.77
.ic v(xdut.vd)  = 0.59

.save all

.control
set num_threads=8
unset askquit
set filetype=ascii

* Settle CMFB with brief tran, then re-OP from the settled state, then AC
tran 10n 200u uic
op
print v(voutp) v(voutn) v(xdut.voutp1) v(xdut.vctrl) v(xdut.pbias) v(xdut.nload) v(xdut.vd)
ac dec 100 100 10G

let vod = v(VOUTP) - v(VOUTN)
let mag_db = 20*log10(abs(vod))
let ph_deg = 180/PI * cph(vod)

meas ac dc_gain_db FIND mag_db AT=1k
meas ac fgbw       WHEN mag_db = 0 CROSS=1
meas ac phase_ugf  FIND ph_deg WHEN mag_db = 0 CROSS=1
let pm = phase_ugf + 180

let f3db_target = dc_gain_db - 3
meas ac f3db       WHEN mag_db = f3db_target CROSS=1

echo ""
echo "================ DIFFERENTIAL AC SUMMARY ================"
print dc_gain_db
print f3db
print fgbw
print phase_ugf
print pm

* Spot phase samples to debug PM convention
let ph_1k    = ph_deg[200]
let ph_100k  = ph_deg[400]
let ph_1Meg  = ph_deg[500]
let ph_10Meg = ph_deg[600]
let ph_100Meg= ph_deg[700]
let mag_1k   = mag_db[200]
let mag_100k = mag_db[400]
let mag_1Meg = mag_db[500]
let mag_10Meg= mag_db[600]
let mag_100Meg=mag_db[700]
print mag_1k mag_100k mag_1Meg mag_10Meg mag_100Meg
print ph_1k ph_100k ph_1Meg ph_10Meg ph_100Meg

write {cicname}.raw
quit
.endc
.end
