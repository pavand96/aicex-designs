*TB LELO_FDA_MILLER — Noise analysis (input-referred, 1 Hz – 100 MHz)
.include ../../../work/xsch/LELO_FDA_MILLER.spice
.option TNOM=27 GMIN=1e-12 reltol=1e-3 srcsteps=20 itl1=500 itl6=300
.option sparse

.param vcm = 'vdda/2'
.param ibias_val = 100u
.param CL_val    = 2.5p
.param vos       = {VOS}

VSS    VSS    0      dc 0
VDD    VDD    0      dc {vdda}
VVCMREF VCMREF 0     dc {vcm}
VVINP  VINP   0      dc {vos}    ac  0.5
VVINN  VINN   0      dc 'vcm'    ac -0.5
IIBIAS VSS    IBIAS  dc {ibias_val}
CLP    VOUTP  VSS    {CL_val}
CLN    VOUTN  VSS    {CL_val}
.include ../xdut.spi

.nodeset v(ibias)        = 0.85
.nodeset v(xdut.pbias)   = 0.64
.nodeset v(xdut.ntail)   = 0.25
.nodeset v(xdut.voutp1)  = 0.77
.nodeset v(xdut.voutn1)  = 0.77
.nodeset v(xdut.vctrl)   = 0.74
.nodeset v(xdut.vd)      = 0.59
.nodeset v(voutp)        = {vcm}
.nodeset v(voutn)        = {vcm}
.nodeset v(xdut.stailp)  = 0.20
.nodeset v(xdut.stailn)  = 0.20
.nodeset v(xdut.nccp)    = {vcm}
.nodeset v(xdut.nccn)    = {vcm}

.ic v(xdut.vctrl)  = 0.74
.ic v(xdut.pbias) = 0.64
.ic v(xdut.ntail) = 0.25
.ic v(voutp)      = {vcm}
.ic v(voutn)      = {vcm}
.ic v(xdut.voutp1)  = 0.77
.ic v(xdut.voutn1)  = 0.77
.ic v(xdut.vd)  = 0.59

.save all

.control
set num_threads=8
unset askquit
set filetype=ascii

* Settle CMFB then re-OP (proven working pattern)
tran 10n 200u uic
op

* Noise analysis — spectrum values are in V/sqrt(Hz) (ASD)
noise v(VOUTP,VOUTN) VVINP dec 50 1 100Meg 1
setplot noise1

* Input-referred noise density at key frequencies
let en_in_1Hz    = inoise_spectrum[0]
let en_in_1kHz   = inoise_spectrum[150]
let en_in_10kHz  = inoise_spectrum[200]
let en_in_100kHz = inoise_spectrum[250]
let en_in_1MHz   = inoise_spectrum[300]
let en_in_10MHz  = inoise_spectrum[350]

* Output noise density
let en_out_1Hz   = onoise_spectrum[0]
let en_out_1kHz  = onoise_spectrum[150]

* Integrated RMS noise: Vrms = sqrt(integral(ASD^2 df))
let inoise_psd = inoise_spectrum * inoise_spectrum
let in_cum = integ(inoise_psd)
let npts = length(in_cum) - 1
let vrms_in = sqrt(in_cum[npts])
let vrms_in_uV = vrms_in * 1e6

echo ""
echo "============ INPUT-REFERRED NOISE DENSITY (nV/sqrt(Hz)) ============"
let en_in_1Hz_nV    = en_in_1Hz * 1e9
let en_in_1kHz_nV   = en_in_1kHz * 1e9
let en_in_10kHz_nV  = en_in_10kHz * 1e9
let en_in_100kHz_nV = en_in_100kHz * 1e9
let en_in_1MHz_nV   = en_in_1MHz * 1e9
let en_in_10MHz_nV  = en_in_10MHz * 1e9
print en_in_1Hz_nV en_in_1kHz_nV en_in_10kHz_nV en_in_100kHz_nV en_in_1MHz_nV en_in_10MHz_nV
echo ""
echo "============ INTEGRATED RMS NOISE (1 Hz .. 100 MHz) ============"
echo "*** Spec: input-referred noise < 50 uVrms ***"
print vrms_in vrms_in_uV

write {cicname}.raw
quit
.endc
.end
