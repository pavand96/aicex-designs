*TB LELO_FDA_MILLER — Noise analysis (input-referred)
.include ../../../work/xsch/LELO_FDA_MILLER.spice
.option TNOM=27 GMIN=1e-12 reltol=1e-3 srcsteps=20 itl1=500 itl6=300
.option sparse

.param vcm = 'vdda/2'
.param ibias_val = 100u
.param CL_val    = 2.5p
.param vos       = {VOS}

VSS    VSS    0      dc 0
VDD    VDD    0      dc {vdda}
VVCMREF VCMREF 0     dc {vcm}
* Single AC source on VINP only (ac=1); VINN is AC ground.
* H(f) = v(VOUTP,VOUTN) / 1.0 = A_diff(f)
* This gives correct inoise = onoise / |A_diff|^2
VVINP  VINP   0      dc {vos}    ac  1.0
VVINN  VINN   0      dc 'vcm'
IIBIAS VSS    IBIAS  dc {ibias_val}
CLP    VOUTP  VSS    {CL_val}
CLN    VOUTN  VSS    {CL_val}
.include ../xdut.spi

.ic v(xdut.vctrl)  = 0.74
.ic v(xdut.pbias) = 0.64
.ic v(xdut.ntail) = 0.25
.ic v(voutp)      = {vcm}
.ic v(voutn)      = {vcm}
.ic v(xdut.voutp1)  = 0.77
.ic v(xdut.voutn1)  = 0.77
.ic v(xdut.vd)  = 0.59

.save all

.control
set num_threads=8
unset askquit
set filetype=ascii

* Settle CMFB via transient
tran 100n 50u uic

* Noise analysis: reference = VVINP (ac=1)
* H(f) = v(VOUTP,VOUTN) / v(VVINP) = A_diff(f) since VVINN has no ac
noise v(VOUTP,VOUTN) VVINP dec 50 1 100Meg 1
setplot noise1

let vn_in_rt  = sqrt(inoise_spectrum)
let vn_out_rt = sqrt(onoise_spectrum)

* Spot noise density (V/sqrt(Hz)) at key frequencies
* dec 50 from 1 Hz to 100 MHz = 400 points (indices 0..399)
* index 0 = 1 Hz, 150 = 1 kHz, 250 = 100 kHz, 300 = 1 MHz, 350 = 10 MHz
let vn_1Hz_in    = vn_in_rt[0]
let vn_1kHz_in   = vn_in_rt[150]
let vn_100kHz_in = vn_in_rt[250]
let vn_1MHz_in   = vn_in_rt[300]
let vn_10MHz_in  = vn_in_rt[350]

let vn_1Hz_out   = vn_out_rt[0]
let vn_1kHz_out  = vn_out_rt[150]
let vn_100kHz_out= vn_out_rt[250]
let vn_10MHz_out = vn_out_rt[350]

* Integrated input-referred RMS noise (1 Hz .. 100 MHz)
let vn_in_cum  = integ(inoise_spectrum)
let vn_out_cum = integ(onoise_spectrum)

* Total integrated RMS
let vn_in_rms_total  = sqrt(vn_in_cum[399])
let vn_out_rms_total = sqrt(vn_out_cum[399])

echo ""
echo "================ INPUT-REFERRED NOISE (V/sqrt(Hz)) ================"
print vn_1Hz_in vn_1kHz_in vn_100kHz_in vn_1MHz_in vn_10MHz_in
echo ""
echo "================ OUTPUT NOISE (V/sqrt(Hz)) ================"
print vn_1Hz_out vn_1kHz_out vn_100kHz_out vn_10MHz_out
echo ""
echo "================ INTEGRATED RMS (1 Hz .. 100 MHz) ================"
print vn_in_rms_total vn_out_rms_total

write {cicname}.raw
quit
.endc
.end
