*TB LELO_FDA_MILLER — Differential noise (input-referred and output)
.include ../../../work/xsch/LELO_FDA_MILLER.spice
.option TNOM=27 GMIN=1e-12 reltol=1e-3 srcsteps=20 itl1=500 itl6=300
.option sparse

.param vcm = 'vdda/2'
.param ibias_val = 100u
.param CL_val    = 2.5p
.param vos       = {VOS}

VSS    VSS    0      dc 0
VDD    VDD    0      dc {vdda}
VVCMREF VCMREF 0     dc {vcm}
VVINP  VINP   0      dc {vos}    ac  0.5
VVINN  VINN   0      dc 'vcm'    ac -0.5
IIBIAS VSS    IBIAS  dc {ibias_val}
CLP    VOUTP  VSS    {CL_val}
CLN    VOUTN  VSS    {CL_val}
.include ../xdut.spi

.ic v(xdut.vctrl)  = 0.74
.ic v(xdut.pbias) = 0.64
.ic v(xdut.ntail) = 0.25
.ic v(voutp)      = {vcm}
.ic v(voutn)      = {vcm}
.ic v(xdut.voutp1)  = 0.77
.ic v(xdut.voutn1)  = 0.77
.ic v(xdut.vd)  = 0.59

.save all

.control
set num_threads=8
unset askquit
set filetype=ascii

* Settle CMFB
tran 100n 50u uic

* Differential output noise: probe (VOUTP - VOUTN) wrt VVINP source
* Frequency range 1 Hz .. 100 MHz (per spec)
noise v(VOUTP,VOUTN) VVINP dec 50 1 100Meg 1
setplot noise1

let vn_in_rt  = sqrt(inoise_spectrum)
let vn_out_rt = sqrt(onoise_spectrum)

let vn_1Hz_in    = vn_in_rt[0]
let vn_1kHz_in   = vn_in_rt[150]
let vn_100kHz_in = vn_in_rt[250]
let vn_1MHz_in   = vn_in_rt[300]
let vn_10MHz_in  = vn_in_rt[350]

let vn_1Hz_out   = vn_out_rt[0]
let vn_1kHz_out  = vn_out_rt[150]
let vn_100kHz_out= vn_out_rt[250]
let vn_10MHz_out = vn_out_rt[350]

let v2_out_cum = integ(onoise_spectrum)

* Output integrated 1 Hz .. 100 MHz (last index for 8 decades * 50 = 400)
let vn_out_rms_total = sqrt(v2_out_cum[399])

* Differential mid-band gain (from companion AC TB at typ).  Override per
* corner with --replace gain.yaml if needed.
let gain_mid_diff = 6800
let vn_in_rms_total = vn_out_rms_total / gain_mid_diff

echo ""
echo "================ INPUT-REFERRED NOISE (V/sqrt(Hz)) ================"
print vn_1Hz_in vn_1kHz_in vn_100kHz_in vn_1MHz_in vn_10MHz_in
echo ""
echo "================ OUTPUT NOISE (V/sqrt(Hz)) ================"
print vn_1Hz_out vn_1kHz_out vn_100kHz_out vn_10MHz_out
echo ""
echo "================ INTEGRATED 1 Hz .. 100 MHz (Vrms) ================"
print vn_in_rms_total vn_out_rms_total gain_mid_diff

write {cicname}.raw
quit
.endc
.end
