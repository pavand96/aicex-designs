*TB LELO_FDA_MILLER — Open-loop large-signal slew (no FB resistors)
.include ../../../work/xsch/LELO_FDA_MILLER.spice
.option TNOM=27 GMIN=1e-12 reltol=1e-3 srcsteps=20 itl1=500 itl6=300

.param AVDD      = 1.8
.param vcm       = 0.9
.param ibias_val = 100u
.param CL_val    = 2.5p

VSS    VSS    0      dc 0
VDD    VDD    0      dc {AVDD}
VVCMREF VCMREF 0     dc {vcm}
IIBIAS  VSS    IBIAS  dc {ibias_val}

* Open-loop differential pulse: VINP_diff = ±150 mV around vcm
VVINP  VINP   0  PWL(0       {vcm}
+                    8u      {vcm}
+                    8.001u  {vcm + 0.075}
+                    16u     {vcm + 0.075}
+                    16.001u {vcm - 0.075}
+                    24u     {vcm - 0.075})
VVINN  VINN   0  PWL(0       {vcm}
+                    8u      {vcm}
+                    8.001u  {vcm - 0.075}
+                    16u     {vcm - 0.075}
+                    16.001u {vcm + 0.075}
+                    24u     {vcm + 0.075})

CLP   VOUTP   VSS   {CL_val}
CLN   VOUTN   VSS   {CL_val}

.include ../xdut.spi

.nodeset v(ibias)        = 0.85
.nodeset v(xdut.pbias)   = 0.64
.nodeset v(xdut.ntail)   = 0.25
.nodeset v(xdut.voutp1)  = 0.77
.nodeset v(xdut.voutn1)  = 0.77
.nodeset v(xdut.vctrl)   = 0.74
.nodeset v(xdut.vd)      = 0.59
.nodeset v(voutp)        = {vcm}
.nodeset v(voutn)        = {vcm}
.nodeset v(xdut.stailp)  = 0.20
.nodeset v(xdut.stailn)  = 0.20

.ic v(xdut.vctrl)   = 0.74
.ic v(xdut.pbias)   = 0.64
.ic v(xdut.ntail)   = 0.25
.ic v(voutp)        = {vcm}
.ic v(voutn)        = {vcm}
.ic v(xdut.voutp1)  = 0.77
.ic v(xdut.voutn1)  = 0.77
.ic v(xdut.vd)      = 0.59

.save v(VOUTP) v(VOUTN)

.control
set num_threads=8
unset askquit
set filetype=ascii

tran 1n 24u

let vod  = v(VOUTP) - v(VOUTN)
let svod = abs(deriv(vod))

* Slew rate: max |dvod/dt| during the +step (8u..9u) and -step (16u..17u)
meas tran sr_rise MAX svod FROM=8u  TO=9u
meas tran sr_fall MAX svod FROM=16u TO=17u

* Settled diff-output amplitude (open loop = output rails at ~ vdd, but
* trimmed by CMFB which holds VOCM = 0.9 V).
meas tran vod_pos AVG vod FROM=14u TO=15.99u
meas tran vod_neg AVG vod FROM=22u TO=23.99u

let sr_v_per_us = sr_rise / 1e6

echo ""
echo "===== OPEN-LOOP LARGE-SIGNAL SLEW ====="
print vod_pos vod_neg sr_rise sr_fall sr_v_per_us

write {cicname}.raw
quit
.endc
.end
