*TB LELO_NMC_3STAGE_FINAL - Open-loop AC via Middlebrook L-break
.include ../../../work/xsch/LELO_NMC_3STAGE_FINAL.spice
.option TNOM=27 GMIN=1e-12 reltol=1e-3 srcsteps=20 itl1=500 itl6=300 abstol=1e-12
.option noopiter gminsteps=20

.param vcm = 'vdda/2'
.param vref_dc = 1.017
.param ibias_val = 10u
.param CL_val    = 10p
.param vos       = {VOS}

VSS    VSS    0      dc 0
VDD    VDD    0      dc {vdda}
* Behavioural CMFB on VREF (slow loop, only sets DC).
* DC: forces VOUT=vcm. AC: BVREF acts at all frequencies, contributes
* extra loop around the opamp. To make CMFB DC-only and not contaminate the
* open-loop AC measurement, we pass it through a heavy LP filter:
* BVREF generates the desired VREF, then RC LP isolates AC.
BVREF_RAW vrefraw 0   v = vcm + 100*(vcm - v(VOUT))
RREFLP    vrefraw VREF 1G
CREFLP    VREF    0    1u
* AC stim at VINP, VINN at vcm (open-loop)
VVINP  VINP   0      dc {vcm+vos}    ac 1
VVINN  VINN   0      dc {vcm}
IIBIAS VSS    IBIAS  dc {ibias_val}
CL     VOUT   VSS    {CL_val}
.include ../xdut.spi

.nodeset v(VOUT)         = {vcm}
.nodeset v(VINN)         = {vcm}
.nodeset v(xdut.IBIAS)   = 0.70
.nodeset v(xdut.vbp)     = 1.10
.nodeset v(xdut.vbn_cas) = 0.90
.nodeset v(xdut.vbp_cas) = 0.85
.nodeset v(xdut.vo1)     = 0.95
.nodeset v(xdut.vo2)     = 0.70
.nodeset v(xdut.vo1d)    = 0.95
.nodeset v(xdut.vo2d)    = 0.65
.nodeset v(xdut.nfp)     = 1.45
.nodeset v(xdut.nfn)     = 1.45
.nodeset v(xdut.nlowp)   = 0.20
.nodeset v(xdut.nlown)   = 0.20
.nodeset v(xdut.ntail1)  = 0.18
.nodeset v(xdut.ptail2)  = 1.62

.save all

.ic v(VOUT)={vcm}
.ic v(VREF)={vcm}
.ic v(xdut.vo1)=0.95
.ic v(xdut.vo2)=1.03

.control
set num_threads=8
unset askquit
set filetype=ascii

* Tran preamble to settle (DC unity-gain since L is short at DC).
tran 100n 200u uic
op
print v(VOUT) v(VINN) v(xdut.vo1) v(xdut.vo2) v(xdut.IBIAS) v(xdut.vbp) v(xdut.vbn_cas) v(xdut.vbp_cas)

ac dec 100 1 10G

* Open-loop transfer: opamp output is v(VOUT), input is v(VINP)-v(VINN) = 1*ac
let a = v(VOUT)
let mag_db = 20*log10(abs(a))
let ph_deg = 180/PI * cph(a)

meas ac dc_gain_db FIND mag_db AT=10
meas ac fgbw       WHEN mag_db = 0 CROSS=1
meas ac phase_ugf  FIND ph_deg WHEN mag_db = 0 CROSS=1
let pm = 180 + phase_ugf

let f3db_target = dc_gain_db - 3
meas ac f3db       WHEN mag_db = f3db_target CROSS=1

echo ""
echo "================ FINAL OPAMP AC SUMMARY ================"
print dc_gain_db
print f3db
print fgbw
print phase_ugf
print pm

write {cicname}.raw
quit
.endc
.end
