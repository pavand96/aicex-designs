*TB LELO_NMC_3STAGE_FINAL - DC operating point in unity-gain feedback
.include ../../../work/xsch/LELO_NMC_3STAGE_FINAL.spice
.option TNOM=27 GMIN=1e-12 reltol=1e-3 srcsteps=20 itl1=500 itl6=300 abstol=1e-12
.option noopiter gminsteps=20

.param vcm = 'vdda/2'
.param vref_dc = 1.017
.param ibias_val = 10u

VSS    VSS    0      dc 0
VDD    VDD    0      dc {vdda}
* Strong CMFB: gain 1000 forces VOUT = vcm via VREF (TB only).
* Long tran preamble settles the loop before OP analysis.
BVREF  VREF   0      v = vcm + 1000*(vcm - v(VOUT))
VVINP  VINP   0      dc {vcm}
VVINN  VINN   0      dc {vcm}
IIBIAS VSS    IBIAS  dc {ibias_val}
CL     VOUT   VSS    10p
.include ../xdut.spi

.nodeset v(VOUT)         = {vcm}
.nodeset v(VINN)         = {vcm}
.nodeset v(xdut.IBIAS)   = 0.70
.nodeset v(xdut.vbp)     = 1.10
.nodeset v(xdut.vbn_cas) = 0.90
.nodeset v(xdut.vbp_cas) = 0.85
.nodeset v(xdut.vo1)     = 0.95
.nodeset v(xdut.vo2)     = 0.70
.nodeset v(xdut.vo1d)    = 0.95
.nodeset v(xdut.vo2d)    = 0.65
.nodeset v(xdut.nfp)     = 1.45
.nodeset v(xdut.nfn)     = 1.45
.nodeset v(xdut.nlowp)   = 0.20
.nodeset v(xdut.nlown)   = 0.20
.nodeset v(xdut.ntail1)  = 0.18
.nodeset v(xdut.ptail2)  = 1.62

.save all

* Strong ICs to seed the desired basin during the tran preamble.
.ic v(VOUT)={vcm}
.ic v(VREF)={vcm}
.ic v(xdut.vo1)=0.95
.ic v(xdut.vo2)=1.03

.control
set num_threads=8
unset askquit
set filetype=ascii

* Settle the loop with a tran preamble before OP
tran 100n 500u uic
op

let i_vdd = abs(i(VDD))
let p_q = i_vdd * 1.8
echo "================ OP SUMMARY ================"
print v(VOUT) v(VINN) v(VINP) v(xdut.vo1) v(xdut.vo2)
print v(xdut.IBIAS) v(xdut.vbp) v(xdut.vbn_cas) v(xdut.vbp_cas)
print v(xdut.nfp) v(xdut.nfn) v(xdut.vo1d) v(xdut.vo2d)
print v(xdut.nlowp) v(xdut.nlown) v(xdut.ntail1) v(xdut.ptail2)
print i_vdd p_q

print @m.xdut.xmtail1.msky130_fd_pr__nfet_01v8[id]
+ @m.xdut.xm1.msky130_fd_pr__nfet_01v8[id]
+ @m.xdut.xm2.msky130_fd_pr__nfet_01v8[id]
+ @m.xdut.xm3p.msky130_fd_pr__pfet_01v8_lvt[id]
+ @m.xdut.xm5p.msky130_fd_pr__pfet_01v8_lvt[id]
+ @m.xdut.xm11n.msky130_fd_pr__nfet_01v8[id]
+ @m.xdut.xm12n.msky130_fd_pr__nfet_01v8[id]
+ @m.xdut.xmtail2p.msky130_fd_pr__pfet_01v8_lvt[id]
+ @m.xdut.xm21p.msky130_fd_pr__pfet_01v8_lvt[id]
+ @m.xdut.xm22p.msky130_fd_pr__pfet_01v8_lvt[id]
+ @m.xdut.xm23n.msky130_fd_pr__nfet_01v8[id]
+ @m.xdut.xm24n.msky130_fd_pr__nfet_01v8[id]
+ @m.xdut.xm31p.msky130_fd_pr__pfet_01v8_lvt[id]
+ @m.xdut.xm32n.msky130_fd_pr__nfet_01v8[id]

* Vds for saturation check
print @m.xdut.xm1.msky130_fd_pr__nfet_01v8[vds]
+ @m.xdut.xm3p.msky130_fd_pr__pfet_01v8_lvt[vds]
+ @m.xdut.xm7p.msky130_fd_pr__pfet_01v8_lvt[vds]
+ @m.xdut.xm9n.msky130_fd_pr__nfet_01v8[vds]
+ @m.xdut.xm11n.msky130_fd_pr__nfet_01v8[vds]
+ @m.xdut.xm21p.msky130_fd_pr__pfet_01v8_lvt[vds]
+ @m.xdut.xm22p.msky130_fd_pr__pfet_01v8_lvt[vds]
+ @m.xdut.xm31p.msky130_fd_pr__pfet_01v8_lvt[vds]
+ @m.xdut.xm32n.msky130_fd_pr__nfet_01v8[vds]

write {cicname}.raw
quit
.endc
.end
