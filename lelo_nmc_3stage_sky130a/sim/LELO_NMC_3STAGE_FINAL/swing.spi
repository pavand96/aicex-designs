*TB LELO_NMC_3STAGE_FINAL - Output swing (slow ramp)
.include ../../../work/xsch/LELO_NMC_3STAGE_FINAL.spice
.option TNOM=27 GMIN=1e-12 reltol=1e-3 srcsteps=20 itl1=500 itl6=300 abstol=1e-12

.param vcm = 'vdda/2'
.param ibias_val = 10u
.param vos       = {VOS}

VSS    VSS    0      dc 0
VDD    VDD    0      dc {vdda}
BVREF_RAW vrefraw 0   v = vcm + 100*(vcm - v(VOUT))
RREFLP    vrefraw VREF 1k
CREFLP    VREF    0    1u  ic=1.0

* Closed-loop gain of 2 (R1=R2=1k) so input range [0..vdd/2] -> output [-vdd/2..vdd/2]
* Easier: keep unity gain, ramp VINP slowly across full rail
RFB    VOUT   VINN   1
VVINP  VINP   0      pulse(0.0 1.8 5u 200u 200u 1n 500u)
IIBIAS VSS    IBIAS  dc {ibias_val}
CL     VOUT   VSS    10p
.include ../xdut.spi

.nodeset v(VOUT) = {vcm}
.nodeset v(VINN) = {vcm}
.nodeset v(VREF) = 1.0
.ic v(VREF) = 1.0

.save v(VOUT) v(VINP)
.control
set num_threads=8
unset askquit
set filetype=ascii
tran 200n 250u uic
* find max/min in steady portion
meas tran vo_max MAX v(VOUT) FROM=180u TO=210u
meas tran vo_min MIN v(VOUT) FROM=10u TO=40u
let swing = vo_max - vo_min
print vo_max vo_min swing
write {cicname}.raw
quit
.endc
.end
