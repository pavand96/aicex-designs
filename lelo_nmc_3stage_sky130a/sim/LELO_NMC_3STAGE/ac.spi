*TB LELO_NMC_3STAGE - Open-loop single-ended AC
.include ../../../work/xsch/LELO_NMC_3STAGE.spice
.option TNOM=27 GMIN=1e-12 reltol=1e-3 srcsteps=20 itl1=500 itl6=300 abstol=1e-12

.param vcm = 'vdda/2'
.param ibias_val = 10u
.param CL_val    = 10p
.param vos       = {VOS}

VSS    VSS    0      dc 0
VDD    VDD    0      dc {vdda}
VVREF  VREF   0      dc {vcm}
VVINP  VINP   0      dc {vcm+vos}    ac 1
VVINN  VINN   0      dc {vcm}
IIBIAS VSS    IBIAS  dc {ibias_val}
CL     VOUT   VSS    {CL_val}
.include ../xdut.spi

.nodeset v(VOUT)        = {vcm}
.nodeset v(xdut.vo1)    = 1.1
.nodeset v(xdut.vo2)    = 0.9
.nodeset v(xdut.vg_in2) = 0.9
.nodeset v(xdut.vg_in3) = 0.9
.nodeset v(xdut.vo1d)   = 1.1
.nodeset v(xdut.vo2d)   = 0.75

.nodeset v(xdut.vo1)   = 0.9
.nodeset v(xdut.vo2)   = 0.75
.nodeset v(VOUT)       = {vcm}
.nodeset v(VINN)       = {vcm}
.nodeset v(xdut.nfp)   = 1.4
.nodeset v(xdut.nfn)   = 1.4
.nodeset v(xdut.vo1d)  = 1.4
.nodeset v(xdut.nlowp) = 0.25
.nodeset v(xdut.nlown) = 0.25
.nodeset v(xdut.ntail1)= 0.25
.nodeset v(xdut.ntail2)= 0.25
.nodeset v(xdut.vo2d)  = 1.4

.save all

.control
set num_threads=8
unset askquit
set filetype=ascii

op
print v(VOUT) v(xdut.vo1) v(xdut.vo2) v(xdut.nfp) v(xdut.nfn)
+ v(xdut.vo1d) v(xdut.nlowp) v(xdut.ntail1) v(xdut.ntail2)
print @m.xdut.xm1.msky130_fd_pr__nfet_01v8[id]
+ @m.xdut.xm2.msky130_fd_pr__nfet_01v8[id]
+ @m.xdut.xm3p.msky130_fd_pr__pfet_01v8_lvt[id]
+ @m.xdut.xm5p.msky130_fd_pr__pfet_01v8_lvt[id]
+ @m.xdut.xm11n.msky130_fd_pr__nfet_01v8[id]
+ @m.xdut.xm12n.msky130_fd_pr__nfet_01v8[id]
+ @m.xdut.xm21.msky130_fd_pr__nfet_01v8[id]
+ @m.xdut.xm22.msky130_fd_pr__nfet_01v8[id]
+ @m.xdut.xm31p.msky130_fd_pr__pfet_01v8_lvt[id]
+ @m.xdut.xm32n.msky130_fd_pr__nfet_01v8[id]

ac dec 100 1 10G

let mag_db = 20*log10(abs(v(VOUT)))
let ph_deg = 180/PI * cph(v(VOUT))

meas ac dc_gain_db FIND mag_db AT=10
meas ac fgbw       WHEN mag_db = 0 CROSS=1
meas ac phase_ugf  FIND ph_deg WHEN mag_db = 0 CROSS=1
let pm = 180 + phase_ugf
* Sign convention: VINP up -> VOUT up so phase ~ 0 at DC; PM = 180 + ph_at_ugf

let f3db_target = dc_gain_db - 3
meas ac f3db       WHEN mag_db = f3db_target CROSS=1

echo ""
echo "================ SINGLE-ENDED AC SUMMARY ================"
print dc_gain_db
print f3db
print fgbw
print phase_ugf
print pm

write {cicname}.raw
quit
.endc
.end
