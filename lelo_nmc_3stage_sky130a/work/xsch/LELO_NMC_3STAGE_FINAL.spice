* LELO_NMC_3STAGE_FINAL - 3-stage NMC opamp with current-mirror biases
* SKY130A, 1.8 V supply, CL = 10 pF
*
* Topology (single-ended):
*   Stage 1: NMOS-input folded cascode -> vo1
*   Stage 2: PMOS-input 5T-OTA          -> vo2
*   Stage 3: PMOS common-source         -> VOUT
*   Cm1 around stage 3, Cm2 around stages 2+3.
*
* Bias: NMOS diode (vbn) and PMOS-LVT diode (vbp) from IBIAS=10uA.
* Cascode biases (vbn_cas, vbp_cas) kept as V-sources for now.
* DC-coupled stages (no AC coupling caps).
* Open-loop OP requires unity-gain DC feedback in TB.

.subckt LELO_NMC_3STAGE_FINAL VSS VDD VOUT IBIAS VINP VINN VREF

.param Vbn_cas = 0.95
.param Vbp_cas = 0.75
VBNC vbn_cas VSS dc 'Vbn_cas'
VBPC vbp_cas VSS dc 'Vbp_cas'

* =====================================================================
* BIAS GENERATOR
* =====================================================================
* IBIAS sinks 10 uA from outside into IBIAS pin (which is the vbn diode drain).
XM_NREF IBIAS IBIAS VSS VSS sky130_fd_pr__nfet_01v8 L=1 W=4 nf=1 m=1
RVBN vbn IBIAS 0

* PMOS reference branch
XM_PREF_SNK vbp vbn VSS VSS sky130_fd_pr__nfet_01v8 L=1 W=4 nf=1 m=1
XM_PREF     vbp vbp VDD VDD sky130_fd_pr__pfet_01v8_lvt L=1 W=8 nf=1 m=1

* =====================================================================
* STAGE 1 : NMOS-input folded cascode
* =====================================================================
XMTAIL1 ntail1 vbn VSS VSS sky130_fd_pr__nfet_01v8 L=1 W=80 nf=16 m=1

XM1   nfp  VINN ntail1 VSS sky130_fd_pr__nfet_01v8 L=1 W=40 nf=8 m=1
XM2   nfn  VINP ntail1 VSS sky130_fd_pr__nfet_01v8 L=1 W=40 nf=8 m=1

XM3p  nfp  vo1d VDD VDD sky130_fd_pr__pfet_01v8_lvt L=2 W=320 nf=32 m=1
XM5p  nfn  vo1d VDD VDD sky130_fd_pr__pfet_01v8_lvt L=2 W=320 nf=32 m=1

XM7p  vo1d vbp_cas nfp VDD sky130_fd_pr__pfet_01v8_lvt L=1 W=160 nf=16 m=1
XM8p  vo1  vbp_cas nfn VDD sky130_fd_pr__pfet_01v8_lvt L=1 W=160 nf=16 m=1

XM9n  vo1d vbn_cas nlowp VSS sky130_fd_pr__nfet_01v8 L=1 W=40 nf=8 m=1
XM10n vo1  vbn_cas nlown VSS sky130_fd_pr__nfet_01v8 L=1 W=40 nf=8 m=1

XM11n nlowp vbn VSS VSS sky130_fd_pr__nfet_01v8 L=2 W=80 nf=16 m=1
XM12n nlown vbn VSS VSS sky130_fd_pr__nfet_01v8 L=2 W=80 nf=16 m=1

* =====================================================================
* STAGE 2 : PMOS-input 5T-OTA
* =====================================================================
XMTAIL2P ptail2 vbp VDD VDD sky130_fd_pr__pfet_01v8_lvt L=1 W=160 nf=16 m=1
XM21p    vo2d   vo1   ptail2 VDD sky130_fd_pr__pfet_01v8_lvt L=1 W=40 nf=8 m=1
XM22p    vo2    VREF  ptail2 VDD sky130_fd_pr__pfet_01v8_lvt L=1 W=40 nf=8 m=1
XM23n    vo2d   vo2d  VSS    VSS sky130_fd_pr__nfet_01v8     L=2 W=20 nf=4 m=1
XM24n    vo2    vo2d  VSS    VSS sky130_fd_pr__nfet_01v8     L=2 W=20 nf=4 m=1

* =====================================================================
* STAGE 3 : PMOS common-source, NMOS sink
* =====================================================================
XM31p VOUT vo2 VDD VDD sky130_fd_pr__pfet_01v8_lvt L=2 W=400 nf=40 m=1
XM32n VOUT vbn VSS VSS sky130_fd_pr__nfet_01v8     L=2 W=240 nf=24 m=1

* =====================================================================
* NESTED MILLER COMPENSATION
* =====================================================================
CCM1 VOUT nm1 8p
RZM1 nm1  vo2 2k
CCM2 VOUT nm2 20p
RZM2 nm2  vo1 1k

.ends
