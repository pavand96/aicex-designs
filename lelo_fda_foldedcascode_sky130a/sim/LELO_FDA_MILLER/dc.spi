*TB LELO_FDA_MILLER — DC sweep to find Vos (VINP needed to make V_OD=0)
.include ../../../work/xsch/LELO_FDA_MILLER.spice
.option TNOM=27 GMIN=1e-12 reltol=1e-3 srcsteps=10 itl1=300

.param vcm = 'vdda/2'
.param ibias_val = 100u
.param CL_val    = 2.5p

VSS    VSS    0      dc 0
VDD    VDD    0      dc {vdda}
VVCMREF VCMREF 0     dc {vcm}
VVINP  VINP   0      dc {vcm} pwl(0 {vcm} 100u {vcm} 110u 0.85 1.110m 0.95)
VVINN  VINN   0      dc {vcm}
IIBIAS VSS    IBIAS  dc {ibias_val}
CLP    VOUTP  VSS    {CL_val}
CLN    VOUTN  VSS    {CL_val}
.include ../xdut.spi

.nodeset v(ibias)        = 1.05
.nodeset v(xdut.pbias)   = 0.92
.nodeset v(xdut.pcas)    = 0.60
.nodeset v(xdut.ncas)    = 0.85
.nodeset v(xdut.ntail)   = 0.23
.nodeset v(xdut.nfp)     = 1.40
.nodeset v(xdut.nfn)     = 1.40
.nodeset v(xdut.nlowp)   = 0.25
.nodeset v(xdut.nlown)   = 0.25
.nodeset v(xdut.vctrl)   = 0.85
.nodeset v(xdut.vd)      = 1.05
.nodeset v(voutp)        = {vcm}
.nodeset v(voutn)        = {vcm}
.nodeset v(xdut.stailp)  = 0.25
.nodeset v(xdut.stailn)  = 0.25

.ic v(xdut.vctrl)  = 0.85
.ic v(xdut.pbias)  = 0.92
.ic v(xdut.pcas)   = 0.60
.ic v(xdut.ncas)   = 0.85
.ic v(xdut.ntail)  = 0.23
.ic v(xdut.nfp)    = 1.40
.ic v(xdut.nfn)    = 1.40
.ic v(xdut.nlowp)  = 0.25
.ic v(xdut.nlown)  = 0.25
.ic v(voutp)       = {vcm}
.ic v(voutn)       = {vcm}
.ic v(xdut.vd)     = 1.05

.save v(voutp) v(voutn) v(vinp) v(vinn)

.control
set num_threads=8
unset askquit
set filetype=ascii
* Differential offset: ramp VVINP from 0.85 -> 0.95 over 1 ms after CMFB settles.
* CMFB holds (voutp+voutn)/2 = vcm. Find VINP where V_OD crosses 0.
let vod_target = 0
tran 100n 1.110m uic
let vod = v(voutp) - v(voutn)
meas tran vos find v(VINP) when vod = vod_target rise=1
print vos
write {cicname}.raw
quit
.endc
.end
