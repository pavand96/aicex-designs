* PMOS-input telescopic/folded cascode + on-chip bias, sky130A, VDD=0.9V
* Low-voltage (Sooch) cascode bias: cascode-gate nodes generated by a single
* diode with 1/4 W/L so VGS = Vt + 2*Vov, fitting in one VGS of headroom.
*
* External ref: IBIAS sinks 10uA from chip pin up to VDD.
*   (i.e. external current sink pulls IREF from VDD into the IBIAS pin;
*    internal PMOS diode at IBIAS sources that current from VDD.)
*
* Mirror plan (everything ratioed off IREF=10uA via integer m), retargeted for 0.9V:
*   NMOS unit:   L=1   W=8  nf=4   (single device draws 10uA when diode-tied at VBIAS3)
*   PMOS unit:   L=1   W=16 nf=4
*
*   M11/M12  NMOS sink         m=4    -> 40 uA each
*   M_TAIL   PMOS tail         m=4    -> 40 uA total  (input pair = 20 uA each)
*   M3/M4    PMOS load mirror  m=2    -> 20 uA each   (KCL @ nbL: 40 = 20 + 20)
*
* Signal-path cascodes carry 20uA each. Total IDD ~ 80uA + biases.
*
* Signal-path cascodes:
*   NMOS cascodes M1A/M2A : L=0.5 W=8 nf=4 m=2 (carry 30uA, low Vov)
*   PMOS cascodes M3A/M4A : L=0.5 W=8 nf=4 m=2

.subckt fc_se_pmos VDD VSS IBIAS VINP VINN VOUTP

* ============================================================
*  BIAS GENERATION  (everything off 10uA master at IBIAS pin)
* ============================================================
* Bias references keep IDENTICAL W and L to signal-path mirror units
* (mandatory for accurate mirroring under PVT) but use larger m so the
* reference device is the parallel combination of more unit cells.
* sigma(deltaVt) ~ 1/sqrt(m*W*L) -> m=8 gives 2.83x tighter Vt under MC,
* and DC OP is preserved because each unit cell sees the same VGS / I.

* --- Master PMOS diode at IBIAS pin -> sets VBP ---
XMP_REF  IBIAS  IBIAS  VDD VDD  sky130_fd_pr__pfet_01v8_lvt L=1 W=16 nf=4 m=8
RBP      VBP    IBIAS  1

* --- VBIAS3 (NMOS sink reference): PMOS source -> NMOS diode at 10uA ---
XMP_VB3  VBIAS3 VBP    VDD VDD  sky130_fd_pr__pfet_01v8_lvt L=1 W=16 nf=4 m=8
XMN_REF  VBIAS3 VBIAS3 VSS VSS  sky130_fd_pr__nfet_01v8_lvt L=0.5 W=4 nf=2 m=8

* ============================================================
*  REPLICA BIAS for VBIAS1 / VBIAS2
* ============================================================
*  Two extra branches that are literal scaled copies of the signal-path
*  stacks, each carrying 10uA. Cascode bias voltages come from diode-tied
*  replica cascode devices sized at the SAME Id/W as the signal path, so
*  Vov and Vt track perfectly across PVT/MC. No analytic "Vt+2Vov" diodes.
*  Signal path is NOT modified.

* --- REPLICA BRANCH A: generates VBIAS1 (PMOS cascode bias) ---
*   Stack: VDD -> XR_M3 diode (PMOS load replica) -> nfLR
*                -> XR_M3A diode (PMOS cascode replica) -> VBIAS1
*                -> XR_S1 NMOS sink (gate=VBIAS3, 10uA mirror) -> VSS
*   M3:  signal m=4 @40uA W128 -> replica m=1 @10uA W128  (Id/W=0.078)
*   M3A: signal m=2 @20uA W256 -> replica m=1 @10uA W128  (Id/W=0.078)
XR_M3    nfLR    nfLR    VDD  VDD  sky130_fd_pr__pfet_01v8_lvt L=1 W=32 nf=4 m=1
XR_M3A   VBIAS1  VBIAS1  nfLR VDD  sky130_fd_pr__pfet_01v8_lvt L=4 W=32 nf=4 m=1
XR_S1    VBIAS1  VBIAS3  VSS  VSS  sky130_fd_pr__nfet_01v8_lvt L=0.5 W=4 nf=2 m=8

* --- REPLICA BRANCH B: generates VBIAS2 (NMOS cascode bias) ---
*   Stack: VDD -> XR_S2 PMOS source (gate=VBP, 10uA mirror) -> VBIAS2
*                -> XR_M1A diode (NMOS cascode replica) -> nbRR
*                -> XR_S11 NMOS sink (gate=VBIAS3, 10uA mirror) -> VSS
*   M1A: signal m=1 nf=4 @20uA W128 -> replica m=1 nf=2 @10uA W64 (Id/W=0.156)
XR_S2    VBIAS2  VBP     VDD  VDD  sky130_fd_pr__pfet_01v8_lvt L=1 W=16 nf=4 m=8
XR_M1A   VBIAS2  VBIAS2  nbRR VSS  sky130_fd_pr__nfet_01v8_lvt L=4 W=32 nf=2 m=1
XR_S11   nbRR    VBIAS3  VSS  VSS  sky130_fd_pr__nfet_01v8_lvt L=0.5 W=4 nf=2 m=8

* ============================================================
*  SIGNAL PATH
* ============================================================

* PMOS tail (40uA total) -- wider unit to keep |VSG_tail| ~ 0.55V at 0.9V VDD
XMTL     ntail   VBP    VDD VDD  sky130_fd_pr__pfet_01v8_lvt L=1 W=16 nf=4 m=4

* PMOS input pair (20uA each)
XM1      nbL     VINP   ntail VDD sky130_fd_pr__pfet_01v8_lvt L=0.5 W=20 nf=4 m=2
XM2      nbR     VINN   ntail VDD sky130_fd_pr__pfet_01v8_lvt L=0.5 W=20 nf=4 m=2

* NMOS bottom sinks (40uA each) -- unit matches XR_M11 (W=4 nf=2 L=0.5)
XM11     nbL     VBIAS3 VSS VSS sky130_fd_pr__nfet_01v8_lvt L=0.5 W=4 nf=2 m=4
XM12     nbR     VBIAS3 VSS VSS sky130_fd_pr__nfet_01v8_lvt L=0.5 W=4 nf=2 m=4

* NMOS wide-swing cascodes (fold current = 20uA each)
XM1A     fL      VBIAS2 nbL VSS sky130_fd_pr__nfet_01v8_lvt L=4 W=32 nf=4 m=1
XM2A     VOUTP   VBIAS2 nbR VSS sky130_fd_pr__nfet_01v8_lvt L=4 W=32 nf=4 m=1

* PMOS wide-swing cascodes (20uA each)
XM3A     fL      VBIAS1 nP3d VDD sky130_fd_pr__pfet_01v8_lvt L=4 W=32 nf=4 m=2
XM4A     VOUTP   VBIAS1 nP4d VDD sky130_fd_pr__pfet_01v8_lvt L=4 W=32 nf=4 m=2

* PMOS top mirror (M3 diode @ fL) -- wider/shorter to keep |VSG| < 0.5V at SS
XM3      nP3d    fL     VDD VDD sky130_fd_pr__pfet_01v8_lvt L=1 W=32 nf=4 m=4
XM4      nP4d    fL     VDD VDD sky130_fd_pr__pfet_01v8_lvt L=1 W=32 nf=4 m=4

.ends fc_se_pmos
