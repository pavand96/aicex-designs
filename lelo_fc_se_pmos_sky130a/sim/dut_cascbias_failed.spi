* PMOS-input telescopic/folded cascode + on-chip bias, sky130A, VDD=0.9V
* Low-voltage (Sooch) cascode bias: cascode-gate nodes generated by a single
* diode with 1/4 W/L so VGS = Vt + 2*Vov, fitting in one VGS of headroom.
*
* External ref: IBIAS sinks 10uA from chip pin up to VDD.
*   (i.e. external current sink pulls IREF from VDD into the IBIAS pin;
*    internal PMOS diode at IBIAS sources that current from VDD.)
*
* Mirror plan (everything ratioed off IREF=10uA via integer m), retargeted for 0.9V:
*   NMOS unit:   L=1   W=8  nf=4   (single device draws 10uA when diode-tied at VBIAS3)
*   PMOS unit:   L=1   W=16 nf=4
*
*   M11/M12  NMOS sink         m=4    -> 40 uA each
*   M_TAIL   PMOS tail         m=4    -> 40 uA total  (input pair = 20 uA each)
*   M3/M4    PMOS load mirror  m=2    -> 20 uA each   (KCL @ nbL: 40 = 20 + 20)
*
* Signal-path cascodes carry 20uA each. Total IDD ~ 80uA + biases.
*
* Signal-path cascodes:
*   NMOS cascodes M1A/M2A : L=0.5 W=8 nf=4 m=2 (carry 30uA, low Vov)
*   PMOS cascodes M3A/M4A : L=0.5 W=8 nf=4 m=2

.subckt fc_se_pmos VDD VSS IBIAS VINP VINN VOUTP

* ============================================================
*  BIAS GENERATION  (everything off 10uA master at IBIAS pin)
* ============================================================
* Bias references keep IDENTICAL W and L to signal-path mirror units
* (mandatory for accurate mirroring under PVT) but use larger m so the
* reference device is the parallel combination of more unit cells.
* sigma(deltaVt) ~ 1/sqrt(m*W*L) -> m=4 gives 2x tighter Vt under MC,
* and DC OP is preserved because each unit cell sees the same VGS / I.

* --- Master PMOS diode at IBIAS pin -> sets VBP (m=8 for matching) ---
*  Master itself stays uncascoded: stacking two diode-tied pfets = 2(Vt+Vov)
*  exceeds VDD=0.9V. Master Vds mismatch vs cascoded mirrors is a small
*  systematic copy error (PVT-stable, removed by trim if needed).
XMP_REF  IBIAS  IBIAS  VDD VDD  sky130_fd_pr__pfet_01v8_lvt L=1 W=16 nf=4 m=8
RBP      VBP    IBIAS  1

* --- VBIAS3 column: SOOCH low-voltage cascoded PMOS mirror -> NMOS diode ---
*  Bot pfet (gate=VBP): |Vds|=|Vov|=0.15V, drain at VDD-0.15=0.75V
*  Cascode pfet (gate=VBIAS1=0.20V): |Vsg|=Vt+Vov=0.55V -> drain free
*  Cascode improves copy accuracy by gm*rds (~30dB) over uncascoded.
XMP_VB3   nVB3i   VBP    VDD   VDD sky130_fd_pr__pfet_01v8_lvt L=1   W=16 nf=4 m=8
XMP_VB3C  VBIAS3  VBIAS1 nVB3i VDD sky130_fd_pr__pfet_01v8_lvt L=0.5 W=16 nf=4 m=8
XMN_REF   VBIAS3  VBIAS3 VSS   VSS sky130_fd_pr__nfet_01v8_lvt L=0.5 W=4  nf=2 m=8
* Startup pull-down: pins nVB3i during TRAN startup, negligible at DC (15nA).
RVB3I     nVB3i   VSS    50MEG

* --- VBIAS2 column: SOOCH cascoded PMOS mirror -> 1/4-aspect NMOS diode ---
*   Sets NMOS cascode bias VBIAS2 = Vt_n + 2*Vov.
XMP_B2    nVB2i   VBP    VDD   VDD sky130_fd_pr__pfet_01v8_lvt L=1   W=16 nf=4 m=8
XMP_B2C   VBIAS2  VBIAS1 nVB2i VDD sky130_fd_pr__pfet_01v8_lvt L=0.5 W=16 nf=4 m=8
XMN_B2    VBIAS2  VBIAS2 VSS   VSS sky130_fd_pr__nfet_01v8_lvt L=2   W=4  nf=2 m=8
RVB2I     nVB2i   VSS    50MEG

* --- VBIAS1 column: 1/4-aspect PMOS diode -> NMOS sink ---
*   Sets PMOS cascode bias VBIAS1 = VDD - (|Vt_p| + 2*|Vov|) ~ 0.2V.
*   NMOS sink left uncascoded: VBIAS1 too low to fit two NMOS Vds_sat.
XMP_B1    VBIAS1  VBIAS1 VDD   VDD sky130_fd_pr__pfet_01v8_lvt L=4 W=16 nf=4 m=8
XMN_B1    VBIAS1  VBIAS3 VSS   VSS sky130_fd_pr__nfet_01v8_lvt L=0.5 W=4 nf=2 m=8
* Startup: weak pull-down on VBIAS1 to avoid parasitic high-VBIAS1 basin.
RVB1S     VBIAS1  VSS    20MEG

* ============================================================
*  SIGNAL PATH
* ============================================================

* PMOS tail (40uA total) -- wider unit to keep |VSG_tail| ~ 0.55V at 0.9V VDD
XMTL     ntail   VBP    VDD VDD  sky130_fd_pr__pfet_01v8_lvt L=1 W=16 nf=4 m=4

* PMOS input pair (20uA each)
XM1      nbL     VINP   ntail VDD sky130_fd_pr__pfet_01v8_lvt L=0.5 W=20 nf=4 m=2
XM2      nbR     VINN   ntail VDD sky130_fd_pr__pfet_01v8_lvt L=0.5 W=20 nf=4 m=2

* NMOS bottom sinks (40uA each) -- unit matches XR_M11 (W=4 nf=2 L=0.5)
XM11     nbL     VBIAS3 VSS VSS sky130_fd_pr__nfet_01v8_lvt L=0.5 W=4 nf=2 m=4
XM12     nbR     VBIAS3 VSS VSS sky130_fd_pr__nfet_01v8_lvt L=0.5 W=4 nf=2 m=4

* NMOS wide-swing cascodes (fold current = 20uA each)
XM1A     fL      VBIAS2 nbL VSS sky130_fd_pr__nfet_01v8_lvt L=4 W=32 nf=4 m=1
XM2A     VOUTP   VBIAS2 nbR VSS sky130_fd_pr__nfet_01v8_lvt L=4 W=32 nf=4 m=1

* PMOS wide-swing cascodes (20uA each)
XM3A     fL      VBIAS1 nP3d VDD sky130_fd_pr__pfet_01v8_lvt L=4 W=32 nf=4 m=2
XM4A     VOUTP   VBIAS1 nP4d VDD sky130_fd_pr__pfet_01v8_lvt L=4 W=32 nf=4 m=2

* PMOS top mirror (M3 diode @ fL) -- wider/shorter to keep |VSG| < 0.5V at SS
XM3      nP3d    fL     VDD VDD sky130_fd_pr__pfet_01v8_lvt L=1 W=32 nf=4 m=4
XM4      nP4d    fL     VDD VDD sky130_fd_pr__pfet_01v8_lvt L=1 W=32 nf=4 m=4

.ends fc_se_pmos
