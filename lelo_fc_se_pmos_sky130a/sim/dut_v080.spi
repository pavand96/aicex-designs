* PMOS-input telescopic/folded cascode + on-chip bias, sky130A, VDD=0.9V
* Low-voltage (Sooch) cascode bias: cascode-gate nodes generated by a single
* diode with 1/4 W/L so VGS = Vt + 2*Vov, fitting in one VGS of headroom.
*
* External ref: IBIAS sinks 10uA from chip pin up to VDD.
*   (i.e. external current sink pulls IREF from VDD into the IBIAS pin;
*    internal PMOS diode at IBIAS sources that current from VDD.)
*
* Mirror plan (everything ratioed off IREF=10uA via integer m), retargeted for 0.9V:
*   NMOS unit:   L=1   W=8  nf=4   (single device draws 10uA when diode-tied at VBIAS3)
*   PMOS unit:   L=1   W=16 nf=4
*
*   M11/M12  NMOS sink         m=4    -> 40 uA each
*   M_TAIL   PMOS tail         m=4    -> 40 uA total  (input pair = 20 uA each)
*   M3/M4    PMOS load mirror  m=2    -> 20 uA each   (KCL @ nbL: 40 = 20 + 20)
*
* Signal-path cascodes carry 20uA each. Total IDD ~ 80uA + biases.
*
* Signal-path cascodes:
*   NMOS cascodes M1A/M2A : L=0.5 W=8 nf=4 m=2 (carry 30uA, low Vov)
*   PMOS cascodes M3A/M4A : L=0.5 W=8 nf=4 m=2

.subckt fc_se_pmos VDD VSS IBIAS VINP VINN VOUTP

* ============================================================
*  BIAS GENERATION  (everything off 10uA master at IBIAS pin)
* ============================================================
* Bias references keep IDENTICAL W and L to signal-path mirror units
* (mandatory for accurate mirroring under PVT) but use larger m so the
* reference device is the parallel combination of more unit cells.
* sigma(deltaVt) ~ 1/sqrt(m*W*L) -> m=4 gives 2x tighter Vt under MC,
* and DC OP is preserved because each unit cell sees the same VGS / I.

* --- Master PMOS diode at IBIAS pin -> sets VBP (m=4 for matching) ---
XMP_REF  IBIAS  IBIAS  VDD VDD  sky130_fd_pr__pfet_01v8_lvt L=1 W=16 nf=4 m=4
RBP      VBP    IBIAS  1

* --- Mirror down: PMOS source (10uA) into NMOS diode -> VBIAS3 ---
XMP_VB3  VBIAS3 VBP    VDD VDD  sky130_fd_pr__pfet_01v8_lvt L=1 W=16 nf=4 m=4
XMN_REF  VBIAS3 VBIAS3 VSS VSS  sky130_fd_pr__nfet_01v8_lvt L=0.5 W=4 nf=2 m=4

* --- VBIAS2 low-voltage NMOS cascode bias (single diode, W/L cut 4x) ---
*   10uA from VBP-mirror PMOS into a 1/4-aspect NMOS diode -> VGS = Vt + 2*Vov.
*   m=4 on both for MC robustness (sigma(Vt) halved).
XMP_B2   VBIAS2  VBP    VDD VDD  sky130_fd_pr__pfet_01v8_lvt L=1 W=16 nf=4 m=4
XMN_B2   VBIAS2  VBIAS2 VSS VSS  sky130_fd_pr__nfet_01v8_lvt L=2 W=4  nf=2 m=4

* --- VBIAS1 low-voltage PMOS cascode bias (single diode, W/L cut 4x) ---
*   10uA pulled by 1/4-aspect PMOS diode to VDD -> |VGS| = |Vt| + 2*|Vov|.
*   m=4 on both for MC robustness.
XMP_B1   VBIAS1  VBIAS1 VDD VDD  sky130_fd_pr__pfet_01v8_lvt L=4 W=16 nf=4 m=4
XMN_B1   VBIAS1  VBIAS3 VSS VSS  sky130_fd_pr__nfet_01v8_lvt L=0.5 W=4 nf=2 m=4

* ============================================================
*  SIGNAL PATH
* ============================================================

* PMOS tail (40uA total) -- wider unit to keep |VSG_tail| ~ 0.55V at 0.9V VDD
XMTL     ntail   VBP    VDD VDD  sky130_fd_pr__pfet_01v8_lvt L=1 W=16 nf=4 m=4

* PMOS input pair (20uA each)
XM1      nbL     VINP   ntail VDD sky130_fd_pr__pfet_01v8_lvt L=0.5 W=20 nf=4 m=2
XM2      nbR     VINN   ntail VDD sky130_fd_pr__pfet_01v8_lvt L=0.5 W=20 nf=4 m=2

* NMOS bottom sinks (40uA each) -- unit matches XR_M11 (W=4 nf=2 L=0.5)
XM11     nbL     VBIAS3 VSS VSS sky130_fd_pr__nfet_01v8_lvt L=0.5 W=4 nf=2 m=4
XM12     nbR     VBIAS3 VSS VSS sky130_fd_pr__nfet_01v8_lvt L=0.5 W=4 nf=2 m=4

* NMOS wide-swing cascodes (fold current = 20uA each)
XM1A     fL      VBIAS2 nbL VSS sky130_fd_pr__nfet_01v8_lvt L=4 W=32 nf=4 m=1
XM2A     VOUTP   VBIAS2 nbR VSS sky130_fd_pr__nfet_01v8_lvt L=4 W=32 nf=4 m=1

* PMOS wide-swing cascodes (20uA each)
XM3A     fL      VBIAS1 nP3d VDD sky130_fd_pr__pfet_01v8_lvt L=4 W=32 nf=4 m=2
XM4A     VOUTP   VBIAS1 nP4d VDD sky130_fd_pr__pfet_01v8_lvt L=4 W=32 nf=4 m=2

* PMOS top mirror (M3 diode @ fL) -- wider/shorter to keep |VSG| < 0.5V at SS
XM3      nP3d    fL     VDD VDD sky130_fd_pr__pfet_01v8_lvt L=1 W=32 nf=4 m=4
XM4      nP4d    fL     VDD VDD sky130_fd_pr__pfet_01v8_lvt L=1 W=32 nf=4 m=4

.ends fc_se_pmos
