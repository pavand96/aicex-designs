* PMOS-input telescopic/folded cascode + on-chip bias, sky130A, VDD=0.9V
* Low-voltage (Sooch) cascode bias: cascode-gate nodes generated by a single
* diode with 1/4 W/L so VGS = Vt + 2*Vov, fitting in one VGS of headroom.
*
* External ref: IBIAS sinks 10uA from chip pin up to VDD.
*   (i.e. external current sink pulls IREF from VDD into the IBIAS pin;
*    internal PMOS diode at IBIAS sources that current from VDD.)
*
* Mirror plan (everything ratioed off IREF=10uA via integer m), retargeted for 0.9V:
*   NMOS unit:   L=1   W=8  nf=4   (single device draws 10uA when diode-tied at VBIAS3)
*   PMOS unit:   L=1   W=16 nf=4
*
*   M11/M12  NMOS sink         m=4    -> 40 uA each
*   M_TAIL   PMOS tail         m=4    -> 40 uA total  (input pair = 20 uA each)
*   M3/M4    PMOS load mirror  m=2    -> 20 uA each   (KCL @ nbL: 40 = 20 + 20)
*
* Signal-path cascodes carry 20uA each. Total IDD ~ 80uA + biases.
*
* Signal-path cascodes:
*   NMOS cascodes M1A/M2A : L=0.5 W=8 nf=4 m=2 (carry 30uA, low Vov)
*   PMOS cascodes M3A/M4A : L=0.5 W=8 nf=4 m=2

.subckt fc_se_pmos VDD VSS IBIAS VINP VINN VOUTP

* ============================================================
*  BIAS GENERATION  (everything off 10uA master at IBIAS pin)
* ============================================================
* Bias references keep IDENTICAL W and L to signal-path mirror units
* (mandatory for accurate mirroring under PVT) but use larger m so the
* reference device is the parallel combination of more unit cells.
* sigma(deltaVt) ~ 1/sqrt(m*W*L) -> m=4 gives 2x tighter Vt under MC,
* and DC OP is preserved because each unit cell sees the same VGS / I.

* --- Master PMOS diode at IBIAS pin -> sets VBP (m=4 for matching) ---
*   VBP = VDD - |Vtp| - |Vov|  (PMOS-source/tail gate-bias rail).
XMP_REF  IBIAS  IBIAS  VDD VDD  sky130_fd_pr__pfet_01v8_lvt L=1 W=16 nf=4 m=4
RBP      VBP    IBIAS  1

* ----- Wide-swing cascode bias generators (Sansen/Razavi style) -----
* Each cascode-gate rail (VBIAS1, VBIAS2) is offset by exactly one Vov
* from the corresponding source-rail (VBP, VBIAS3) using a 10k poly drop
* resistor carrying the 10 uA bias current.  Bottom (or top) device is a
* W/L replica of the signal-path mirror unit so Vt cancels between bias
* and signal cells.  No bootstrapping -> single DC solution per leg.

* NMOS bias leg: VBP -> PMOS source -> VBIAS2 -> R_n -> VBIAS3 -> NMOS diode -> VSS.
*   I = 10 uA, R_n = 10k -> drop = 100 mV = Vov.
*   VBIAS3 = Vt + Vov,  VBIAS2 = VBIAS3 + Vov = Vt + 2*Vov.
XMP_NLEG VBIAS2  VBP    VDD VDD  sky130_fd_pr__pfet_01v8_lvt L=1 W=16 nf=4 m=4
RN_BIAS  VBIAS2  VBIAS3 10k
XMN_NDIO VBIAS3  VBIAS3 VSS VSS  sky130_fd_pr__nfet_01v8_lvt L=1 W=4 nf=2 m=8

* PMOS bias leg: VDD -> PMOS diode replica -> VBP_int=VBP -> R_p -> VBIAS1 -> NMOS sink -> VSS.
*   I = 10 uA pulled by NMOS sink (gate=VBIAS3, mirrors bottom-diode current).
*   R_p = 10k -> drop = 100 mV = |Vov|.
*   VBIAS1 = VBP - |Vov| = VDD - |Vtp| - 2|Vov|.
RP_BIAS  VBP     VBIAS1 10k
XMN_PSNK VBIAS1  VBIAS3 VSS VSS  sky130_fd_pr__nfet_01v8_lvt L=1 W=4 nf=2 m=8

* ============================================================
*  SIGNAL PATH
* ============================================================

* PMOS tail (40uA total) -- wider unit to keep |VSG_tail| ~ 0.55V at 0.9V VDD
XMTL     ntail   VBP    VDD VDD  sky130_fd_pr__pfet_01v8_lvt L=1 W=16 nf=4 m=4

* PMOS input pair (20uA each) -- m=4 to halve sigma(deltaVt)
XM1      nbL     VINP   ntail VDD sky130_fd_pr__pfet_01v8_lvt L=0.5 W=20 nf=4 m=4
XM2      nbR     VINN   ntail VDD sky130_fd_pr__pfet_01v8_lvt L=0.5 W=20 nf=4 m=4

* NMOS bottom sinks (40uA each) -- L=1 m=8 for higher rds + tight matching
XM11     nbL     VBIAS3 VSS VSS sky130_fd_pr__nfet_01v8_lvt L=1 W=4 nf=2 m=8
XM12     nbR     VBIAS3 VSS VSS sky130_fd_pr__nfet_01v8_lvt L=1 W=4 nf=2 m=8

* NMOS wide-swing cascodes (fold current = 20uA each) -- W=16 to push nbR down out of triode
XM1A     fL      VBIAS2 nbL VSS sky130_fd_pr__nfet_01v8_lvt L=4 W=16 nf=4 m=1
XM2A     VOUTP   VBIAS2 nbR VSS sky130_fd_pr__nfet_01v8_lvt L=4 W=16 nf=4 m=1

* PMOS wide-swing cascodes (20uA each)  -- m=4 doubles W to drop |Vds_sat|
XM3A     fL      VBIAS1 nP3d VDD sky130_fd_pr__pfet_01v8_lvt L=4 W=32 nf=4 m=4
XM4A     VOUTP   VBIAS1 nP4d VDD sky130_fd_pr__pfet_01v8_lvt L=4 W=32 nf=4 m=4

* PMOS top mirror (M3 diode @ fL) -- L=2 for higher rds + tighter matching
XM3      nP3d    fL     VDD VDD sky130_fd_pr__pfet_01v8_lvt L=2 W=32 nf=4 m=8
XM4      nP4d    fL     VDD VDD sky130_fd_pr__pfet_01v8_lvt L=2 W=32 nf=4 m=8

.ends fc_se_pmos
