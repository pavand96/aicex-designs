* OP testbench: unity feedback, on-chip bias, IBIAS sinks to VDD.

.param VDD_VAL = 0.9
.param VCM     = 0.3
.param IREF    = 10u
.param CL_VAL  = 5p

.include dut.spi

XDUT VDD VSS IBIAS VINP VINN VOUTP fc_se_pmos

VDD     VDD     0   dc {VDD_VAL}
VSS     VSS     0   dc 0
* IBIAS sinks IREF from VDD into the IBIAS pin
IBIAS_S IBIAS   VDD   dc {IREF}

* Unity feedback
RFB     VOUTP   VINN  1
VVINP   VINP    0     dc {VCM}
CL      VOUTP   VSS   {CL_VAL}

.option TNOM=27 GMIN=1e-12 reltol=1e-3 srcsteps=20 itl1=500 itl6=300 noopiter gminsteps=20
.save all

.control
set num_threads=4
unset askquit
set filetype=ascii
tran 10n 100u uic
op
echo ""
echo "================ OP REPORT ================"
print v(IBIAS) v(xdut.vbp) v(xdut.vbias1) v(xdut.vbias2)
print v(xdut.ntail) v(xdut.nbL) v(xdut.nbR) v(xdut.fL) v(xdut.np3d) v(xdut.np4d) v(VOUTP)
print v(xdut.vbias3)
print -i(vdd)
quit
.endc
.end
