* tb_template.spice
.include "lelo_generated.spice"

VSS VSS 0 dc 0
VDD VDD 0 dc 1.8
VIN VIN 0 dc {VIN_DC} ac 1

XDUT VOUT VSS VDD VIN LELO_EX1

.op
.ac dec 100 1 1e9

.control
set filetype=ascii
op
write op.raw
ac dec 100 1 1e9
write ac.raw
quit
.endc

.end
