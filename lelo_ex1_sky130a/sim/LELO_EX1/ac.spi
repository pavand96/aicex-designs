*TB_SUN_TR_SKY130NM/TB_NCM
*----------------------------------------------------------------
* Include
*----------------------------------------------------------------
.include ../../../work/xsch/LELO_EX1.spice

*-----------------------------------------------------------------
* OPTIONS
*-----------------------------------------------------------------
.option TNOM=27 GMIN=1e-15 reltol=1e-3

*-----------------------------------------------------------------
* PARAMETERS
*-----------------------------------------------------------------
.param AVDD = 1.8
.param vin_dc = 0.6

*-----------------------------------------------------------------
* SOURCES
*-----------------------------------------------------------------
VSS   VSS   0    dc 0
VDD   VDD   0    dc {AVDD}
VIN   VIN   0    dc {vin_dc} ac 0.01

*-----------------------------------------------------------------
* DUT
*-----------------------------------------------------------------
.include ../xdut.spi

*----------------------------------------------------------------
* SAVE
*----------------------------------------------------------------

.save v(VIN) v(VOUT)
*----------------------------------------------------------------
* NGSPICE control
*----------------------------------------------------------------
.control
set num_threads=8
unset askquit
set filetype=ascii

op
ac dec 10 100 100G

write {cicname}.raw v(VIN) v(VOUT)
quit
.endc

.end
