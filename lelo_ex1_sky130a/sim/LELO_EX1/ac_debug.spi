*TB_LELO_EX1 - Simplified AC test
*-----------------------------------------------------------------
* Include
*-----------------------------------------------------------------
#ifdef Lay
.include ../../../work/lpe/LELO_EX1_lpe.spi
#else
.include ../../../work/xsch/LELO_EX1.spice
#endif

*-----------------------------------------------------------------
* OPTIONS
*-----------------------------------------------------------------
.option TNOM=27 GMIN=1e-15 reltol=1e-3 method=gear

*-----------------------------------------------------------------
* PARAMETERS
*-----------------------------------------------------------------
.param AVDD = 1.8
.param vin_dc = 0.6

*-----------------------------------------------------------------
* SOURCES
*-----------------------------------------------------------------
VSS   VSS   0    dc 0
VDD   VDD   0    dc {AVDD}
VIN   VIN   0    dc {vin_dc} ac 0.01

*-----------------------------------------------------------------
* DUT
*-----------------------------------------------------------------
.include ../xdut.spi

*----------------------------------------------------------------
* SAVE
*----------------------------------------------------------------
.save all

*----------------------------------------------------------------
* NGSPICE control
*----------------------------------------------------------------
.control
set num_threads=8
unset askquit
set filetype=ascii
set wr_vecnames
set wr_singlescale

op
print all

ac dec 5 100 100G

write {cicname}_debug.raw
quit
.endc

.end
