*TB_SUN_TR_SKY130NM/TB_NCM
*----------------------------------------------------------------
* Include
*----------------------------------------------------------------
#ifdef Lay
.include ../../../work/lpe/LELO_EX1_lpe.spi
#else
.include ../../../work/xsch/LELO_EX1.spice
#endif

*-----------------------------------------------------------------
* OPTIONS
*-----------------------------------------------------------------
.option TNOM=27 GMIN=1e-15 reltol=1e-3

*-----------------------------------------------------------------
* PARAMETERS
*-----------------------------------------------------------------
.param AVDD = 1.8
.param vin_val = 0.8

*-----------------------------------------------------------------
* SOURCES
*-----------------------------------------------------------------
VSS   VSS   0    dc 0
VDD   VDD   0    dc {AVDD}
VIN   VIN   0    dc {vin_val}

*-----------------------------------------------------------------
* DUT
*-----------------------------------------------------------------
.include ../xdut.spi

*----------------------------------------------------------------
* SAVE
*----------------------------------------------------------------
.save all
.save v(VIN) v(VOUT) i(VDD)

*----------------------------------------------------------------
* NGSPICE control
*----------------------------------------------------------------
.control
set num_threads=8
unset askquit
set filetype=ascii

op
write {cicname}.raw v(VIN) v(VOUT) i(VDD)
quit
.endc

.end
