*TB_SUN_TR_SKY130NM/TB_NCM
*----------------------------------------------------------------
* Include
*----------------------------------------------------------------
#ifdef Lay
.include ../../../work/lpe/LELO_EX1_lpe.spi
#else
.include ../../../work/xsch/LELO_EX1.spice
#endif

*-----------------------------------------------------------------
* OPTIONS
*-----------------------------------------------------------------
.option TNOM=27 GMIN=1e-15 reltol=1e-3

*-----------------------------------------------------------------
* PARAMETERS
*-----------------------------------------------------------------
.param AVDD = 1.8

*-----------------------------------------------------------------
* SOURCES
*-----------------------------------------------------------------
VSS   VSS   0    dc 0
VDD   VDD   0    dc {AVDD}
VIN   VIN   0    dc 0

*-----------------------------------------------------------------
* DUT
*-----------------------------------------------------------------
.include ../xdut.spi

*----------------------------------------------------------------
* SAVE
*----------------------------------------------------------------
.save all
.save v(VIN)
.save v(VOUT)
.save i(VDD)

*----------------------------------------------------------------
* NGSPICE control
*----------------------------------------------------------------
.control
set num_threads=8
set color0=white
set color1=black
unset askquit

dc VIN 0 1.8 0.01

write
quit
.endc

.end
