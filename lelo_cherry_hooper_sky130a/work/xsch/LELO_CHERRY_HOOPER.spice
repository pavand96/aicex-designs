** Cherry-Hooper differential amplifier — with internal bias mirror
** Pinout: VSS VDD VOUTP VOUTN IBIAS VINP VINN
**   IBIAS sinks ~10 uA into the NMOS diode (XMNB).
**   Internal nodes vbiasn / vbiasp are mirrored from there.
**   Tail mirror ratio 1:10 (XMNB W=8, MT1/MT2 W=80) -> ~100 uA per branch
**   Load mirror ratio 1:10 (XMPB W=2, MI1..MI4 W=20)  -> ~100 uA per load
**   All devices nf=1 so ngspice device-access strings work.

.subckt LELO_CHERRY_HOOPER VSS VDD VOUTP VOUTN IBIAS VINP VINN

* ------------- Bias generator -------------
* NMOS diode at IBIAS pin: external source pushes 10 uA into IBIAS,
* drain current flows down through XMNB, setting vbiasn = VGS_NMOS @ 10 uA.
XMNB IBIAS IBIAS VSS VSS sky130_fd_pr__nfet_01v8 L=1.0 W=8 nf=1 m=1

* Mirror leg: NMOS gated by IBIAS sinks 10 uA from a PMOS diode;
* the PMOS diode drives vbiasp (= VDD - VSG_PMOS @ 10 uA).
XMNREF vbiasp IBIAS VSS VSS sky130_fd_pr__nfet_01v8 L=1.0 W=8 nf=1 m=1
XMPB   vbiasp vbiasp VDD VDD sky130_fd_pr__pfet_01v8 L=1.0 W=2 nf=1 m=1

* ------------- Stage 1 -------------
XM1 nA  VINP ntail1 VSS sky130_fd_pr__nfet_01v8 L=0.5 W=60 nf=1 m=1
XM2 nB  VINN ntail1 VSS sky130_fd_pr__nfet_01v8 L=0.5 W=60 nf=1 m=1
XMT1 ntail1 IBIAS VSS VSS sky130_fd_pr__nfet_01v8 L=1.0 W=80 nf=1 m=1
XMI3 nA vbiasp VDD VDD sky130_fd_pr__pfet_01v8 L=1.0 W=20 nf=1 m=1
XMI4 nB vbiasp VDD VDD sky130_fd_pr__pfet_01v8 L=1.0 W=20 nf=1 m=1

* ------------- Stage 2 -------------
XM3 VOUTN nA ntail2 VSS sky130_fd_pr__nfet_01v8 L=0.5 W=15 nf=1 m=1
XM4 VOUTP nB ntail2 VSS sky130_fd_pr__nfet_01v8 L=0.5 W=15 nf=1 m=1
XMT2 ntail2 IBIAS VSS VSS sky130_fd_pr__nfet_01v8 L=1.0 W=80 nf=1 m=1
XMI1 VOUTN vbiasp VDD VDD sky130_fd_pr__pfet_01v8 L=1.0 W=20 nf=1 m=1
XMI2 VOUTP vbiasp VDD VDD sky130_fd_pr__pfet_01v8 L=1.0 W=20 nf=1 m=1

* ------------- Shunt feedback -------------
RF1 VOUTN nA  16k
RF2 VOUTP nB  16k

.ends
.end
