*TB LELO_CHERRY_HOOPER — Transient: small-signal settling + large-signal slew
.include ../../../work/xsch/LELO_CHERRY_HOOPER.spice

.option TNOM=27 GMIN=1e-12 reltol=1e-3 srcsteps=10 itl1=300

.param AVDD      = 1.8
.param vcm       = 0.9
.param ibias_val = 10u
.param CL_val    = 100f

.param vstep_small = 10m
.param vstep_large = 200m
.param tstep_edge  = 50p
.param tstart      = 5n
.param tstart2     = 25n

VSS    VSS    0      dc 0
VDD    VDD    0      dc {AVDD}
IIBIAS VSS    IBIAS  dc {ibias_val}

VVINP  VINP   0   PWL(0 {vcm}
+ {tstart}                {vcm}
+ {tstart+tstep_edge}     {vcm + vstep_small/2}
+ {tstart2}               {vcm + vstep_small/2}
+ {tstart2+tstep_edge}    {vcm + vstep_large/2})
VVINM  VINN   0   PWL(0 {vcm}
+ {tstart}                {vcm}
+ {tstart+tstep_edge}     {vcm - vstep_small/2}
+ {tstart2}               {vcm - vstep_small/2}
+ {tstart2+tstep_edge}    {vcm - vstep_large/2})

CL_P   VOUTP  VSS    {CL_val}
CL_N   VOUTN  VSS    {CL_val}

.include ../xdut.spi

.nodeset v(ibias)         = 0.70
.nodeset v(xdut.vbiasp)   = 0.40
.nodeset v(xdut.ntail1)   = 0.20
.nodeset v(xdut.ntail2)   = 0.30
.nodeset v(xdut.nA)       = 1.10
.nodeset v(xdut.nB)       = 1.10
.nodeset v(voutp)         = 1.10
.nodeset v(voutn)         = 1.10

.save v(VOUTP) v(VOUTN) v(VINP) v(VINN)

.control
set num_threads=8
unset askquit
set filetype=ascii

tran 20p 50n

let vodiff = v(voutp) - v(voutn)

* === SMALL-SIGNAL step (10 mV diff at t=5 ns) ===
meas tran vo_init_s   AVG  vodiff  FROM=1n   TO=4n
meas tran vo_fin_s    AVG  vodiff  FROM=18n  TO=23n
meas tran vo_pp_s     PP   vodiff  FROM=5n   TO=18n

* === LARGE-SIGNAL step (200 mV diff at t=25 ns) ===
meas tran vo_init_l   AVG  vodiff  FROM=22n  TO=24n
meas tran vo_fin_l    AVG  vodiff  FROM=45n  TO=49n

* Slew rate: peak |dv/dt| during the rising edge
let svd     = abs(deriv(vodiff))
meas tran sr_pos    MAX  svd  FROM=25n  TO=27n
meas tran vo_pp_l   PP   vodiff  FROM=25n  TO=49n

echo ""
echo "============ SMALL-SIGNAL (10 mV diff) =========="
print vo_init_s vo_fin_s vo_pp_s
echo ""
echo "============ LARGE-SIGNAL (200 mV diff) =========="
print vo_init_l vo_fin_l vo_pp_l
print sr_pos
echo "  Slew rate (V/s) = sr_pos"

write {cicname}.raw
quit
.endc
.end
