*TB Cherry-Hooper — AC for Monte-Carlo (gain + BW only, robust)
.include ../../../work/xsch/LELO_CHERRY_HOOPER.spice
.option TNOM=27 GMIN=1e-12 reltol=1e-3 srcsteps=10 itl1=300

.param AVDD      = 1.8
.param vcm       = 0.9
.param ibias_val = 10u
.param CL_val    = 100f

VSS    VSS    0      dc 0
VDD    VDD    0      dc {AVDD}
VVINP  VINP   0      dc {vcm} ac  0.5
VVINM  VINN   0      dc {vcm} ac -0.5
IIBIAS VSS    IBIAS  dc {ibias_val}
CL_P   VOUTP  VSS    {CL_val}
CL_N   VOUTN  VSS    {CL_val}
.include ../xdut.spi

.nodeset v(ibias)         = 0.70
.nodeset v(xdut.vbiasp)   = 0.40
.nodeset v(xdut.ntail1)   = 0.20
.nodeset v(xdut.ntail2)   = 0.30
.nodeset v(xdut.nA)       = 1.10
.nodeset v(xdut.nB)       = 1.10
.nodeset v(voutp)         = 1.10
.nodeset v(voutn)         = 1.10

.save all

.control
set num_threads=8
unset askquit
set filetype=ascii
ac dec 100 1 10G
let vodiff      = v(voutp) - v(voutn)
let gain_mag_db = 20*log10(abs(vodiff)) - 20*log10(2)
meas ac dc_gain_db FIND gain_mag_db AT=1
let f3db_target = dc_gain_db - 3
meas ac f3db       WHEN gain_mag_db = f3db_target
print dc_gain_db
print f3db
write {cicname}.raw
quit
.endc
.end
