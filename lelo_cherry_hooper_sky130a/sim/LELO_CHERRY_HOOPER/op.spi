*TB LELO_CHERRY_HOOPER — Operating Point
.include ../../../work/xsch/LELO_CHERRY_HOOPER.spice

.option TNOM=27
.temp 27

.param AVDD     = 1.8
.param vcm      = 0.9
.param vbiasn   = 0.7    $ NMOS tail gate bias
.param vbiasp   = 0.4

VSS    VSS    0      dc 0
VDD    VDD    0      dc {AVDD}
VVINP  VINP   0      dc {vcm}
VVINM  VINN   0      dc {vcm}
VBN    VBIASN VSS    dc {vbiasn}
VBP    VBIASP VSS    dc {vbiasp}

.include ../xdut.spi

.nodeset v(voutp)        = 0.9
.nodeset v(voutn)        = 0.9
.nodeset v(xdut.nA)      = 0.9
.nodeset v(xdut.nB)      = 0.9
.nodeset v(xdut.ntail1)  = 0.25
.nodeset v(xdut.ntail2)  = 0.25

.save all

.control
set num_threads=8
unset askquit
set filetype=ascii

op

echo "================================================"
echo "  CHERRY-HOOPER OP — node voltages"
echo "================================================"
print v(vdd) v(vss) v(vbiasn) v(vbiasp)
print v(vinp) v(vinn)
print v(xdut.ntail1) v(xdut.ntail2)
print v(xdut.nA) v(xdut.nB)
print v(voutp) v(voutn)

echo ""
echo "--- Branch currents (A) ---"
echo "M1 ID:"
print @m.xdut.xm1.msky130_fd_pr__nfet_01v8[id]
echo "M2 ID:"
print @m.xdut.xm2.msky130_fd_pr__nfet_01v8[id]
echo "M3 ID:"
print @m.xdut.xm3.msky130_fd_pr__nfet_01v8[id]
echo "M4 ID:"
print @m.xdut.xm4.msky130_fd_pr__nfet_01v8[id]
echo "MT1 (ISS1) ID:"
print @m.xdut.xmt1.msky130_fd_pr__nfet_01v8[id]
echo "MT2 (ISS2) ID:"
print @m.xdut.xmt2.msky130_fd_pr__nfet_01v8[id]
echo "I1 (PMOS load VOUTN) ID:"
print @m.xdut.xmi1.msky130_fd_pr__pfet_01v8[id]
echo "I3 (PMOS load nA) ID:"
print @m.xdut.xmi3.msky130_fd_pr__pfet_01v8[id]

echo ""
echo "--- Small-signal parameters ---"
echo "M1 gm, gds:"
print @m.xdut.xm1.msky130_fd_pr__nfet_01v8[gm] @m.xdut.xm1.msky130_fd_pr__nfet_01v8[gds]
echo "M3 gm, gds:"
print @m.xdut.xm3.msky130_fd_pr__nfet_01v8[gm] @m.xdut.xm3.msky130_fd_pr__nfet_01v8[gds]
echo "I1 gds (PMOS load):"
print @m.xdut.xmi1.msky130_fd_pr__pfet_01v8[gds]

echo ""
echo "--- Saturation check ---"
echo "M1 vds, vdsat:"
print @m.xdut.xm1.msky130_fd_pr__nfet_01v8[vds] @m.xdut.xm1.msky130_fd_pr__nfet_01v8[vdsat]
echo "M3 vds, vdsat:"
print @m.xdut.xm3.msky130_fd_pr__nfet_01v8[vds] @m.xdut.xm3.msky130_fd_pr__nfet_01v8[vdsat]
echo "MT1 vds, vdsat:"
print @m.xdut.xmt1.msky130_fd_pr__nfet_01v8[vds] @m.xdut.xmt1.msky130_fd_pr__nfet_01v8[vdsat]
echo "I1 vds, vdsat:"
print @m.xdut.xmi1.msky130_fd_pr__pfet_01v8[vds] @m.xdut.xmi1.msky130_fd_pr__pfet_01v8[vdsat]

write {cicname}.raw
quit
.endc
.end
