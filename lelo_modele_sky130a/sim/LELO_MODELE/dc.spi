*TB_LELO_MODELE - DC Parametric Sweep
*Sweep VIN from 0V to 1.8V to extract DC operating point
*Measures: ID vs VIN, gain vs VIN
*-----------------------------------------------------------------
* Include
*-----------------------------------------------------------------
#ifdef Lay
.include ../../../work/lpe/LELO_MODELE_lpe.spi
#else
.include ../../../work/xsch/LELO_MODELE.spice
#endif

*-----------------------------------------------------------------
* OPTIONS
*-----------------------------------------------------------------
.option TNOM=27 GMIN=1e-15 reltol=1e-3

*-----------------------------------------------------------------
* PARAMETERS
*-----------------------------------------------------------------
.param AVDD = 1.8
.param RL_val = 100k

*-----------------------------------------------------------------
* SOURCES
*-----------------------------------------------------------------
VSS   VSS   0    dc 0
VDD   VDD   0    dc {AVDD}
VIN   VIN   0    dc 0

*-----------------------------------------------------------------
* LOAD RESISTOR for realistic operation
*-----------------------------------------------------------------
RL    VDD   VOUT   {RL_val}

*-----------------------------------------------------------------
* DUT
*-----------------------------------------------------------------
.include ../xdut.spi

*----------------------------------------------------------------
* SAVE
*----------------------------------------------------------------
.save all
.save v(VIN)
.save v(VOUT)
.save i(VDD)

*----------------------------------------------------------------
* NGSPICE control
*----------------------------------------------------------------
.control
set num_threads=8
set color0=white
set color1=black
unset askquit

dc VIN 0 1.8 0.01

write
quit

.end
