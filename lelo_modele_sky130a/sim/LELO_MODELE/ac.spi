*TB_LELO_MODELE - AC Frequency Response
*Fixed bias point, AC sweep for small-signal analysis
*Extract: Frequency response, gain, bandwidth
*-----------------------------------------------------------------
* Include
*-----------------------------------------------------------------
#ifdef Lay
.include ../../../work/lpe/LELO_MODELE_lpe.spi
#else
.include ../../../work/xsch/LELO_MODELE.spice
#endif

*-----------------------------------------------------------------
* OPTIONS
*-----------------------------------------------------------------
.option TNOM=27 GMIN=1e-15 reltol=1e-3

*-----------------------------------------------------------------
* PARAMETERS
*-----------------------------------------------------------------
.param AVDD = 1.8
.param vin_dc = 0.6
.param RL_val = 50k

*-----------------------------------------------------------------
* SOURCES - DC bias + AC signal
*-----------------------------------------------------------------
VSS   VSS    0         dc 0
VDD   VDD    0         dc {AVDD}
VIN   VIN    0         dc {vin_dc} ac 1.0

*-----------------------------------------------------------------
* LOAD RESISTOR for realistic operation
*-----------------------------------------------------------------
RL    VDD   VOUT   {RL_val}

*-----------------------------------------------------------------
* DUT
*-----------------------------------------------------------------
.include ../xdut.spi

*----------------------------------------------------------------
* SAVE
*----------------------------------------------------------------
.save all
.save v(VIN) v(VOUT) i(VDD)

*----------------------------------------------------------------
* NGSPICE control
*----------------------------------------------------------------
.control
set num_threads=8
unset askquit
set filetype=ascii

op
ac dec 10 100 100G

write {cicname}.raw v(VIN) v(VOUT) i(VDD)
quit
