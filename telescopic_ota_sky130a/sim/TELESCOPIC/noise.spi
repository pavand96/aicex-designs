*TB TELESCOPIC — Noise (input-referred, 1 Hz - 100 MHz)
.include ../../../work/xsch/TELESCOPIC.spice
.option TNOM=27 GMIN=1e-12 reltol=1e-3 srcsteps=20 itl1=500 itl6=300
.option sparse

.param vcm       = '{VCM}'
.param ibias_val = 10u
.param CL_val    = 2p
.param RL_val    = 100k

VSS    VSS    0      dc 0
VDD    VDD    0      dc {vdda}
VVIP   VIP    0      dc {vcm}   ac  0.5
VVIN   VIN    0      dc {vcm}   ac -0.5
IIBIAS VSS    IBIAS  dc {ibias_val}
CLO    VOUT   VSS    {CL_val}
RLO    VOUT   VSS    {RL_val}
.include ../xdut.spi

.nodeset v(ibias)        = 0.65
.nodeset v(xdut.ntail)   = 0.20
.nodeset v(xdut.nd1)     = 0.35
.nodeset v(xdut.nd2)     = 0.35
.nodeset v(xdut.na)      = 1.05
.nodeset v(xdut.nb)      = 1.55
.nodeset v(vout)         = {vcm}

.save all

.control
set num_threads=8
unset askquit
set filetype=ascii

tran 1n 50u uic
op

* Noise at VOUT (single-ended); input source VVIP
noise v(VOUT) VVIP dec 50 1 100Meg 1
setplot noise1

* Input-referred density at key frequencies
let en_in_1Hz    = inoise_spectrum[0]
let en_in_1kHz   = inoise_spectrum[150]
let en_in_10kHz  = inoise_spectrum[200]
let en_in_100kHz = inoise_spectrum[250]
let en_in_1MHz   = inoise_spectrum[300]
let en_in_10MHz  = inoise_spectrum[350]

* Integrated RMS: Vrms = sqrt(integral(ASD^2 df))
let inoise_psd = inoise_spectrum * inoise_spectrum
let in_cum = integ(inoise_psd)
let npts = length(in_cum) - 1
let vrms_in = sqrt(in_cum[npts])
let vrms_in_uV = vrms_in * 1e6

echo ""
echo "============ INPUT-REFERRED NOISE DENSITY (nV/sqrt(Hz)) ============"
let en_in_1Hz_nV    = en_in_1Hz * 1e9
let en_in_1kHz_nV   = en_in_1kHz * 1e9
let en_in_10kHz_nV  = en_in_10kHz * 1e9
let en_in_100kHz_nV = en_in_100kHz * 1e9
let en_in_1MHz_nV   = en_in_1MHz * 1e9
let en_in_10MHz_nV  = en_in_10MHz * 1e9
print en_in_1Hz_nV en_in_1kHz_nV en_in_10kHz_nV en_in_100kHz_nV en_in_1MHz_nV en_in_10MHz_nV

echo ""
echo "============ INTEGRATED RMS NOISE (1 Hz .. 100 MHz) ============"
print vrms_in vrms_in_uV

write {cicname}.raw
quit
.endc
.end
