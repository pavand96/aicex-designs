*cicsimgen ac

.option SEED=1

*Nothing here

.param mc_mm_switch=0
.param mc_pr_switch=0
.include "/opt/pdk/share/pdk/sky130A/libs.ref/sky130_fd_pr/spice/sky130_fd_pr__nfet_01v8__ss.pm3.spice"
.include "/opt/pdk/share/pdk/sky130A/libs.ref/sky130_fd_pr/spice/sky130_fd_pr__nfet_01v8__mismatch.corner.spice"
.include "/opt/pdk/share/pdk/sky130A/libs.ref/sky130_fd_pr/spice/sky130_fd_pr__nfet_01v8_lvt__ss.corner.spice"
.include "/opt/pdk/share/pdk/sky130A/libs.ref/sky130_fd_pr/spice/sky130_fd_pr__nfet_01v8_lvt__mismatch.corner.spice"
.include "/opt/pdk/share/pdk/sky130A/libs.ref/sky130_fd_pr/spice/sky130_fd_pr__pfet_01v8__ss.corner.spice"
.include "/opt/pdk/share/pdk/sky130A/libs.ref/sky130_fd_pr/spice/sky130_fd_pr__pfet_01v8__mismatch.corner.spice"
.include "/opt/pdk/share/pdk/sky130A/libs.ref/sky130_fd_pr/spice/sky130_fd_pr__pfet_01v8_lvt__ss.corner.spice"
.include "/opt/pdk/share/pdk/sky130A/libs.ref/sky130_fd_pr/spice/sky130_fd_pr__pfet_01v8_lvt__mismatch.corner.spice"
.include "/opt/pdk/share/pdk/sky130A/libs.tech/ngspice/corners/ss/nonfet.spice"
.include "/opt/pdk/share/pdk/sky130A/libs.ref/sky130_fd_pr/spice/sky130_fd_pr__npn_05v5__s.corner.spice"
.include "/opt/pdk/share/pdk/sky130A/libs.tech/ngspice/all.spice"
.include "/opt/pdk/share/pdk/sky130A/libs.tech/ngspice/r+c/res_high__cap_high.spice"
.include "/opt/pdk/share/pdk/sky130A/libs.tech/ngspice/r+c/res_high__cap_high__lin.spice"
.include "/opt/pdk/share/pdk/sky130A/libs.tech/ngspice/corners/ss/specialized_cells.spice"

.lib "../../../tech/ngspice/temperature.spi" Tl

.lib "../../../tech/ngspice/supply.spi" Vt

*TB TELESCOPIC — Open-loop AC (single-ended output)
.include ../../../work/xsch/TELESCOPIC.spice
.option TNOM=27 GMIN=1e-12 reltol=1e-3 srcsteps=20 itl1=500 itl6=300 abstol=1e-12

.param vcm       = '0.9'
.param ibias_val = 10u
.param CL_val    = 2p
.param RL_val    = 1G

VSS    VSS    0      dc 0
VDD    VDD    0      dc {vdda}
* Differential AC stim: ±0.5 on VIP/VIN → Vid = 1
VVIP   VIP    0      dc {vcm}   ac  0.5
VVIN   VIN    0      dc {vcm}   ac -0.5
IIBIAS VSS    IBIAS  dc {ibias_val}

* Load: 2 pF || 100 kΩ to VSS (per spec)
CLO    VOUT   VSS    {CL_val}
RLO    VOUT   VSS    {RL_val}

* DC-only bias clamp: huge inductor pins VOUT=VCM at DC,
* opens at AC so we measure true open-loop gain.
LBIAS  VOUT   nbias  1G
VBIAS_OUT nbias VSS dc {vcm}

.include ../xdut.spi

.nodeset v(ibias)        = 0.65
.nodeset v(xdut.ntail)   = 0.25
.nodeset v(xdut.nd1)     = 0.45
.nodeset v(xdut.nd2)     = 0.45
.nodeset v(xdut.na)      = 1.20
.nodeset v(xdut.np2)     = 1.40
.nodeset v(vout)         = {vcm}

.save all

.control
set num_threads=8
unset askquit
set filetype=ascii

* Direct OP (simple mirror is well-conditioned)
op
print v(vout) v(xdut.na) v(xdut.np2) v(xdut.nd1) v(xdut.nd2) v(xdut.ntail)
ac dec 100 1 1G

let vo = v(VOUT)
let mag_db = 20*log10(abs(vo))
let ph_deg = 180/PI * cph(vo)

meas ac dc_gain_db FIND mag_db AT=10
meas ac fgbw       WHEN mag_db = 0 CROSS=1
meas ac phase_ugf  FIND ph_deg WHEN mag_db = 0 CROSS=1
let pm = phase_ugf + 180

let f3db_target = dc_gain_db - 3
meas ac f3db       WHEN mag_db = f3db_target CROSS=1

* Output swing for gain > 40 dB metric: find freq where gain drops to 40 dB
meas ac f_40db     WHEN mag_db = 40 CROSS=1

echo ""
echo "================ OPEN-LOOP AC SUMMARY ================"
print dc_gain_db
print f3db
print fgbw
print phase_ugf
print pm
print f_40db

* Spot magnitude/phase data
let mag_1   = mag_db[100]
let mag_10  = mag_db[200]
let mag_100 = mag_db[300]
let mag_1k  = mag_db[400]
let mag_10k = mag_db[500]
let mag_100k= mag_db[600]
let mag_1M  = mag_db[700]
let mag_10M = mag_db[800]
let ph_1    = ph_deg[100]
let ph_10   = ph_deg[200]
let ph_100  = ph_deg[300]
let ph_1k   = ph_deg[400]
let ph_10k  = ph_deg[500]
let ph_100k = ph_deg[600]
let ph_1M   = ph_deg[700]
let ph_10M  = ph_deg[800]
print mag_1 mag_10 mag_100 mag_1k mag_10k mag_100k mag_1M mag_10M
print ph_1 ph_10 ph_100 ph_1k ph_10k ph_100k ph_1M ph_10M

write ac_SchGtKssTlVt.raw
quit
.endc
.end
