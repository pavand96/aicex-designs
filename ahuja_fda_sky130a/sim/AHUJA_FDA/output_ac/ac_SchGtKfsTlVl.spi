*cicsimgen ac

.option SEED=1

*Nothing here

.param mc_mm_switch=0
.param mc_pr_switch=0
.include "/opt/pdk/share/pdk/sky130A/libs.ref/sky130_fd_pr/spice/sky130_fd_pr__nfet_01v8__fs.pm3.spice"
.include "/opt/pdk/share/pdk/sky130A/libs.ref/sky130_fd_pr/spice/sky130_fd_pr__nfet_01v8__mismatch.corner.spice"
.include "/opt/pdk/share/pdk/sky130A/libs.ref/sky130_fd_pr/spice/sky130_fd_pr__nfet_01v8_lvt__fs.corner.spice"
.include "/opt/pdk/share/pdk/sky130A/libs.ref/sky130_fd_pr/spice/sky130_fd_pr__nfet_01v8_lvt__mismatch.corner.spice"
.include "/opt/pdk/share/pdk/sky130A/libs.ref/sky130_fd_pr/spice/sky130_fd_pr__pfet_01v8__fs.corner.spice"
.include "/opt/pdk/share/pdk/sky130A/libs.ref/sky130_fd_pr/spice/sky130_fd_pr__pfet_01v8__mismatch.corner.spice"
.include "/opt/pdk/share/pdk/sky130A/libs.ref/sky130_fd_pr/spice/sky130_fd_pr__pfet_01v8_lvt__fs.corner.spice"
.include "/opt/pdk/share/pdk/sky130A/libs.ref/sky130_fd_pr/spice/sky130_fd_pr__pfet_01v8_lvt__mismatch.corner.spice"
.include "/opt/pdk/share/pdk/sky130A/libs.tech/ngspice/corners/fs/nonfet.spice"
.include "/opt/pdk/share/pdk/sky130A/libs.ref/sky130_fd_pr/spice/sky130_fd_pr__npn_05v5__t.corner.spice"
.include "/opt/pdk/share/pdk/sky130A/libs.tech/ngspice/all.spice"
.include "/opt/pdk/share/pdk/sky130A/libs.tech/ngspice/r+c/res_typical__cap_typical.spice"
.include "/opt/pdk/share/pdk/sky130A/libs.tech/ngspice/r+c/res_typical__cap_typical__lin.spice"
.include "/opt/pdk/share/pdk/sky130A/libs.tech/ngspice/corners/fs/specialized_cells.spice"

.lib "../../../tech/ngspice/temperature.spi" Tl

.lib "../../../tech/ngspice/supply.spi" Vl

*TB AHUJA_FDA — open-loop AC: DC gain, UGF, PM, GM
.include ../../../work/xsch/AHUJA_FDA.spice
.option TNOM=27 reltol=1e-4 abstol=1e-12 vntol=1e-7 noopiter gminsteps=20

.param vcm = '0.9'

VSS    VSS    0    dc 0
VDD    VDD    0    dc {vdda}

* Differential AC excitation: +0.5 on VIP, -0.5 on VIN -> Vid_ac = 1
VVIP   VIP    0    dc {vcm} ac  0.5
VVIN   VIN    0    dc {vcm} ac -0.5
VVCM   VCM    0    dc {vcm}

* External bandgap-style current reference: 100 uA into IBIAS (sinks to VSS via diode)
IBIAS_REF VDD IBIAS dc 100u

* Static CMFB driver disabled - internal transistor CMFB now closed
RCMFB_PROBE nVcmfb 0 1G

CLP    VOP    VSS  10p
CLN    VON    VSS  10p

.include ../xdut.spi

* Minimal corner-portable bootstrap: only hint topological roles, let CMFB settle.
.nodeset v(vop)            = {vcm}
.nodeset v(von)            = {vcm}
.nodeset v(xdut.v_cms)     = {vcm}
.nodeset v(xdut.stail_cm)  = 1.5
.nodeset v(xdut.n_diode)   = 0.55

.save all

.control
set num_threads=8
unset askquit
set filetype=ascii

op
ac dec 50 1 1G

* Differential output magnitude/phase
let vod = v(vop) - v(von)
let mag_db = db(vod)
let ph_deg = 180/PI * cph(vod)

meas ac dc_gain_db find mag_db at=1
meas ac fgbw      when mag_db=0 fall=1
meas ac ph_at_fgbw find ph_deg when mag_db=0 fall=1
meas ac f_180     when ph_deg=-180 fall=1
meas ac gm_db     find mag_db when ph_deg=-180 fall=1

* PM = 180 + phase_at_UGF (phase already wrapped around -180 at HF)
let pm = 180 + ph_at_fgbw

echo "==== AC results ===="
print dc_gain_db fgbw ph_at_fgbw pm f_180 gm_db

* dump bode for plotting
wrdata ac.csv mag_db ph_deg

.endc
.end
