*TB AHUJA_FDA — DC sweep nVcmfb to find quiescent point
.include ../../../work/xsch/AHUJA_FDA.spice
.option TNOM=27 reltol=1e-4 abstol=1e-12 vntol=1e-7

.param vcm = '{VCM}'

VSS    VSS    0    dc 0
VDD    VDD    0    dc {vdda}
VVIP   VIP    0    dc {vcm}
VVIN   VIN    0    dc {vcm}
VVCM   VCM    0    dc {vcm}
* IBIAS not used by current netlist; tie to VSS via a 1G to avoid floating port
RIBDUM IBIAS  VSS  1G

VVCMFB nVcmfb 0   dc 0.6

CLP    VOP    VSS  10p
CLN    VON    VSS  10p

.include ../xdut.spi

.save all

.control
set num_threads=8
unset askquit
set filetype=ascii

dc VVCMFB 0.5 1.6 0.025
let vocm = (v(VOP)+v(VON))/2

echo "==== nVcmfb sweep ===="
print v(v-sweep) v(VOP) v(VON) vocm v(xdut.apos) v(xdut.bpos) v(xdut.ntail)

write {cicname}.raw
quit
.endc
.end
